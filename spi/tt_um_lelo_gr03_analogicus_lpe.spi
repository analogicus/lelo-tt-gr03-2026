* NGSPICE file created from tt_um_lelo_gr03_analogicus.ext - technology: sky130A

* Replacing the lpe port list (../tech/scripts/fixlpe)
.subckt tt_um_lelo_gr03_analogicus uo_out<7> uo_out<6> uo_out<5> uo_out<4> uo_out<3> uo_out<2> uo_out<1> uo_out<0>
+ uio_out<7> uio_out<6> uio_out<5> uio_out<4> uio_out<3> uio_out<2> uio_out<1> uio_out<0> uio_oe<7> uio_oe<6> uio_oe<5> uio_oe<4> uio_oe<3> uio_oe<2> uio_oe<1> uio_oe<0> VDPWR VGND
+ ui_in<7> ui_in<6> ui_in<5> ui_in<4> ui_in<3> ui_in<2> ui_in<1> ui_in<0> uio_in<7> uio_in<6> uio_in<5> uio_in<4> uio_in<3> uio_in<2> uio_in<1> uio_in<0> ena rst_n clk
*.subckt tt_um_lelo_gr03_analogicus uo_out<7> uo_out<6> uo_out<5> uo_out<4> uo_out<3>
*+ uo_out<2> uo_out<1> uo_out<0> uio_out<7> uio_out<6> uio_out<5> uio_out<4> uio_out<3>
*+ uio_out<2> uio_out<1> uio_out<0> uio_oe<7> uio_oe<6> uio_oe<5> uio_oe<4> uio_oe<3>
*+ uio_oe<2> uio_oe<1> uio_oe<0> VDPWR VGND ui_in<7> ui_in<6> ui_in<5> ui_in<4> ui_in<3>
*+ ui_in<2> ui_in<1> ui_in<0> uio_in<7> uio_in<6> uio_in<5> uio_in<4> uio_in<3> uio_in<2>
*+ uio_in<1> uio_in<0> ena rst_n clk
X0 a_7444_17154# a_7228_15234# VGND sky130_fd_pr__res_high_po w=0.36 l=7.36
X1 LELO_GR03_1.x7.x21.S LELO_GR03_1.x7.x21.G LELO_GR03_1.x7.x20.G VDPWR sky130_fd_pr__pfet_01v8 ad=0.848 pd=4.26 as=0.528 ps=2.26 w=1.6 l=0.94
X2 LELO_GR03_1.x10.XA5.A LELO_GR03_1.x10.XA7.CN LELO_GR03_1.x10.XA3.MP1.S VDPWR sky130_fd_pr__pfet_01v8 ad=0.468 pd=2.84 as=0.288 ps=1.54 w=0.9 l=0.16
X3 a_11962_7464# a_12178_5544# VGND sky130_fd_pr__res_high_po w=0.36 l=7.36
X4 LELO_GR03_1.x7.x21.G LELO_GR03_1.x7.x20.G LELO_GR03_1.x7.x21.S VDPWR sky130_fd_pr__pfet_01v8 ad=0.528 pd=2.26 as=0.848 ps=4.26 w=1.6 l=0.94
X5 LELO_GR03_1.x1.x11.D LELO_GR03_1.x1.x21.OUT LELO_GR03_1.x7.INN VDPWR sky130_fd_pr__pfet_01v8 ad=0.5088 pd=2.98 as=0.3168 ps=1.62 w=0.96 l=0.94
X6 VGND VGND LELO_GR03_1.x1.XQ2.Emitter sky130_fd_pr__pnp_05v5_W3p40L3p40
**devattr s=462400,2720
X7 LELO_GR03_1.BIAS_CIRCUIT2_0.xb7.D a_11746_9122# VGND sky130_fd_pr__res_high_po w=0.36 l=7.36
X8 LELO_GR03_1.x7.x21.G LELO_GR03_1.x7.x21.G LELO_GR03_1.x7.x21.S VDPWR sky130_fd_pr__pfet_01v8 ad=0.528 pd=2.26 as=0.848 ps=4.26 w=1.6 l=0.94
X9 VGND VGND LELO_GR03_1.x1.XQ2.Emitter sky130_fd_pr__pnp_05v5_W3p40L3p40
**devattr s=462400,2720
X10 LELO_GR03_1.x7.x7<2>.S LELO_GR03_1.x7.INN LELO_GR03_1.x7.x20.G VGND sky130_fd_pr__nfet_01v8 ad=0.848 pd=4.26 as=0.528 ps=2.26 w=1.6 l=0.94
X11 LELO_GR03_1.x7.x21.G LELO_GR03_1.x12<1>.A LELO_GR03_1.x7.x7<2>.S VGND sky130_fd_pr__nfet_01v8 ad=0.528 pd=2.26 as=0.848 ps=4.26 w=1.6 l=0.94
X12 VGND VGND LELO_GR03_1.x1.XQ2.Emitter sky130_fd_pr__pnp_05v5_W3p40L3p40
**devattr s=462400,2720
X13 LELO_GR03_1.x7.PWRUP_N_1V8 ui_in<0> VDPWR VDPWR sky130_fd_pr__pfet_01v8 ad=0.468 pd=2.84 as=0.468 ps=2.84 w=0.9 l=0.16
X14 LELO_GR03_1.x7.x21.S LELO_GR03_1.x7.PWRUP_N_1V8 VDPWR VDPWR sky130_fd_pr__pfet_01v8 ad=0.8352 pd=3.46 as=1.4112 ps=6.74 w=2.88 l=0.22
X15 LELO_GR03_1.x10.XA6.MP1.S LELO_GR03_1.x10.XA6.A VDPWR VDPWR sky130_fd_pr__pfet_01v8 ad=0.288 pd=1.54 as=0.468 ps=2.84 w=0.9 l=0.16
X16 LELO_GR03_1.x10.XA7.MP1.S uo_out<0> LELO_GR03_1.x10.XA7.MN0.S VGND sky130_fd_pr__nfet_01v8 ad=0.288 pd=1.54 as=0.288 ps=1.54 w=0.9 l=0.16
X17 LELO_GR03_1.BIAS_CIRCUIT2_0.xa5.N a_11746_5544# VGND sky130_fd_pr__res_high_po w=0.36 l=7.36
X18 VGND VGND LELO_GR03_1.x1.XQ2<3>.Emitter sky130_fd_pr__pnp_05v5_W3p40L3p40
**devattr s=462400,2720
X19 LELO_GR03_1.x1.x14.D LELO_GR03_1.x1.x21.OUT LELO_GR03_1.x1.x17.D VDPWR sky130_fd_pr__pfet_01v8 ad=0.3168 pd=1.62 as=0.5088 ps=2.98 w=0.96 l=0.94
X20 LELO_GR03_1.x7.x20.G LELO_GR03_1.x7.x21.G LELO_GR03_1.x7.x21.S VDPWR sky130_fd_pr__pfet_01v8 ad=0.528 pd=2.26 as=0.848 ps=4.26 w=1.6 l=0.94
X21 LELO_GR03_1.x1.XQ2<3>.Emitter a_5288_15234# VGND sky130_fd_pr__res_high_po w=0.36 l=7.36
X22 VGND LELO_GR03_1.x1.x21.OUT LELO_GR03_1.x1.x21.OUT VGND sky130_fd_pr__nfet_01v8 ad=0.848 pd=4.26 as=0.528 ps=2.26 w=1.6 l=0.94
X23 VGND LELO_GR03_1.x12<1>.A sky130_fd_pr__cap_mim_m3_1 l=5 w=5
X24 LELO_GR03_1.BIAS_CIRCUIT2_0.xc2.S LELO_GR03_1.x7.VB_N LELO_GR03_1.x7.VB_N VGND sky130_fd_pr__nfet_01v8 ad=0.848 pd=4.26 as=0.528 ps=2.26 w=1.6 l=0.94
X25 VGND VGND LELO_GR03_1.x1.XQ2.Emitter sky130_fd_pr__pnp_05v5_W3p40L3p40
**devattr s=462400,2720
X26 LELO_GR03_1.x1.x15.G LELO_GR03_1.x1.x21.OUT LELO_GR03_1.x1.x18.G VGND sky130_fd_pr__nfet_01v8 ad=0.848 pd=4.26 as=0.528 ps=2.26 w=1.6 l=0.94
X27 LELO_GR03_1.BIAS_CIRCUIT2_0.xa6.N a_14770_9122# VGND sky130_fd_pr__res_high_po w=0.36 l=7.36
X28 VGND LELO_GR03_1.x10.CK LELO_GR03_1.x12<1>.A VGND sky130_fd_pr__nfet_01v8 ad=0.848 pd=4.26 as=0.528 ps=2.26 w=1.6 l=0.94
X29 LELO_GR03_1.x10.XA1.MN1.S LELO_GR03_1.x10.CK VGND VGND sky130_fd_pr__nfet_01v8 ad=0.288 pd=1.54 as=0.468 ps=2.84 w=0.9 l=0.16
X30 VGND VGND LELO_GR03_1.x1.XQ2.Emitter sky130_fd_pr__pnp_05v5_W3p40L3p40
**devattr s=462400,2720
X31 LELO_GR03_1.x1.x21.OUT LELO_GR03_1.x1.x21.x11<1>.A sky130_fd_pr__cap_mim_m3_1 l=5 w=5
X32 VGND LELO_GR03_1.x7.PWRUP_1V8 LELO_GR03_1.x7.x8.S VGND sky130_fd_pr__nfet_01v8 ad=1.4112 pd=6.74 as=0.8352 ps=3.46 w=2.88 l=0.22
X33 VGND VGND LELO_GR03_1.x1.XQ2.Emitter sky130_fd_pr__pnp_05v5_W3p40L3p40
**devattr s=462400,2720
X34 LELO_GR03_1.x1.x21.x6.G LELO_GR03_1.x1.x21.INP LELO_GR03_1.x1.x21.x3<1>.D VDPWR sky130_fd_pr__pfet_01v8_lvt ad=0.528 pd=2.26 as=0.848 ps=4.26 w=1.6 l=0.94
X35 VGND LELO_GR03_1.x12<1>.A sky130_fd_pr__cap_mim_m3_1 l=5 w=5
X36 LELO_GR03_1.x7.x10.D LELO_GR03_1.x7.x6.G LELO_GR03_1.x7.x8.S VGND sky130_fd_pr__nfet_01v8 ad=0.528 pd=2.26 as=0.848 ps=4.26 w=1.6 l=0.94
X37 LELO_GR03_1.x1.x21.x3<1>.S LELO_GR03_1.x7.PWRUP_N_1V8 VDPWR VDPWR sky130_fd_pr__pfet_01v8 ad=0.8352 pd=3.46 as=1.4112 ps=6.74 w=2.88 l=0.22
X38 LELO_GR03_1.BIAS_CIRCUIT2_0.xa6.N a_14770_5544# VGND sky130_fd_pr__res_high_po w=0.36 l=7.36
X39 VGND LELO_GR03_1.x7.PWRUP_1V8 LELO_GR03_1.BIAS_CIRCUIT2_0.xc2.S VGND sky130_fd_pr__nfet_01v8 ad=1.4112 pd=6.74 as=0.8352 ps=3.46 w=2.88 l=0.22
X40 LELO_GR03_1.x1.x21.x6.S LELO_GR03_1.x1.x21.x4.G LELO_GR03_1.x1.x21.x6.G VGND sky130_fd_pr__nfet_01v8 ad=0.848 pd=4.26 as=0.528 ps=2.26 w=1.6 l=0.94
R0 uio_oe<2> JNWTR_TIEL_CV_0.Y sky130_fd_pr__res_generic_m4 w=0.3 l=0.3
X41 LELO_GR03_1.x7.x20.G LELO_GR03_1.x7.INN LELO_GR03_1.x7.x7<2>.S VGND sky130_fd_pr__nfet_01v8 ad=0.528 pd=2.26 as=0.848 ps=4.26 w=1.6 l=0.94
X42 VGND VGND LELO_GR03_1.x1.XQ2.Emitter sky130_fd_pr__pnp_05v5_W3p40L3p40
**devattr s=462400,2720
X43 LELO_GR03_1.x1.x18.S LELO_GR03_1.x1.x18.G LELO_GR03_1.x1.x21.OUT VDPWR sky130_fd_pr__pfet_01v8 ad=0.848 pd=4.26 as=0.528 ps=2.26 w=1.6 l=0.94
X44 LELO_GR03_1.x10.XA5.A LELO_GR03_1.x10.XA7.C LELO_GR03_1.x10.XA4.MP1.S VDPWR sky130_fd_pr__pfet_01v8 ad=0.468 pd=2.84 as=0.288 ps=1.54 w=0.9 l=0.16
X45 VGND VGND LELO_GR03_1.x1.XQ2.Emitter sky130_fd_pr__pnp_05v5_W3p40L3p40
**devattr s=462400,2720
X46 LELO_GR03_1.x1.x21.x3<1>.D LELO_GR03_1.x1.XQ2<3>.Emitter LELO_GR03_1.x1.x21.x4.G VDPWR sky130_fd_pr__pfet_01v8_lvt ad=0.848 pd=4.26 as=0.528 ps=2.26 w=1.6 l=0.94
X47 a_13690_11042# a_13474_9122# VGND sky130_fd_pr__res_high_po w=0.36 l=7.36
X48 uo_out<0> LELO_GR03_1.x10.D VDPWR VDPWR sky130_fd_pr__pfet_01v8 ad=0.468 pd=2.84 as=0.468 ps=2.84 w=0.9 l=0.16
X49 LELO_GR03_1.x1.x21.OUT LELO_GR03_1.x1.x18.S sky130_fd_pr__cap_mim_m3_1 l=5 w=5
X50 LELO_GR03_1.x7.x7<2>.S LELO_GR03_1.x7.INN LELO_GR03_1.x7.x20.G VGND sky130_fd_pr__nfet_01v8 ad=0.848 pd=4.26 as=0.528 ps=2.26 w=1.6 l=0.94
X51 LELO_GR03_1.x1.x21.x6.S LELO_GR03_1.x7.PWRUP_1V8 VGND VGND sky130_fd_pr__nfet_01v8 ad=0.8352 pd=3.46 as=1.4112 ps=6.74 w=2.88 l=0.22
X52 LELO_GR03_1.x7.x8.S LELO_GR03_1.x7.PWRUP_1V8 VGND VGND sky130_fd_pr__nfet_01v8 ad=0.8352 pd=3.46 as=1.4112 ps=6.74 w=2.88 l=0.22
X53 LELO_GR03_1.x1.x18.S LELO_GR03_1.x7.PWRUP_N_1V8 VDPWR VDPWR sky130_fd_pr__pfet_01v8 ad=0.8352 pd=3.46 as=1.4112 ps=6.74 w=2.88 l=0.22
X54 LELO_GR03_1.x1.XQ2.Emitter a_10188_5354# VGND sky130_fd_pr__res_high_po w=0.36 l=7.36
X55 a_13690_7464# a_13474_5544# VGND sky130_fd_pr__res_high_po w=0.36 l=7.36
X56 VGND LELO_GR03_1.x12<1>.A sky130_fd_pr__cap_mim_m3_1 l=5 w=5
X57 LELO_GR03_1.x7.x21.S LELO_GR03_1.x7.PWRUP_N_1V8 VDPWR VDPWR sky130_fd_pr__pfet_01v8 ad=0.8352 pd=3.46 as=1.4112 ps=6.74 w=2.88 l=0.22
X58 VDPWR VDPWR LELO_GR03_1.x10.XA7.MP1.S VDPWR sky130_fd_pr__pfet_01v8 ad=0.288 pd=1.54 as=0.468 ps=2.84 w=0.9 l=0.16
X59 VGND VGND LELO_GR03_1.x1.XQ2.Emitter sky130_fd_pr__pnp_05v5_W3p40L3p40
**devattr s=462400,2720
X60 LELO_GR03_1.x1.x18.G LELO_GR03_1.x1.x18.G LELO_GR03_1.x1.x18.S VDPWR sky130_fd_pr__pfet_01v8 ad=0.528 pd=2.26 as=0.848 ps=4.26 w=1.6 l=0.94
X61 VDPWR LELO_GR03_1.x7.PWRUP_N_1V8 LELO_GR03_1.x1.x21.x3<1>.S VDPWR sky130_fd_pr__pfet_01v8 ad=1.4112 pd=6.74 as=0.8352 ps=3.46 w=2.88 l=0.22
X62 a_13258_11042# a_13474_9122# VGND sky130_fd_pr__res_high_po w=0.36 l=7.36
X63 LELO_GR03_1.x10.XA7.CN LELO_GR03_1.x10.XA7.C VGND VGND sky130_fd_pr__nfet_01v8 ad=0.468 pd=2.84 as=0.468 ps=2.84 w=0.9 l=0.16
X64 LELO_GR03_1.BIAS_CIRCUIT2_0.xb6.S LELO_GR03_1.x7.VB_N LELO_GR03_1.x1.VB_P VGND sky130_fd_pr__nfet_01v8 ad=0.848 pd=4.26 as=0.528 ps=2.26 w=1.6 l=0.94
R1 uio_oe<1> JNWTR_TIEL_CV_0.Y sky130_fd_pr__res_generic_m4 w=0.3 l=0.3
X65 VGND LELO_GR03_1.x12<1>.A sky130_fd_pr__cap_mim_m3_1 l=5 w=5
X66 LELO_GR03_1.x1.x21.x6.G LELO_GR03_1.x1.x21.INP LELO_GR03_1.x1.x21.x3<1>.D VDPWR sky130_fd_pr__pfet_01v8_lvt ad=0.528 pd=2.26 as=0.848 ps=4.26 w=1.6 l=0.94
X67 a_13258_7464# a_13474_5544# VGND sky130_fd_pr__res_high_po w=0.36 l=7.36
X68 LELO_GR03_1.x7.x8.S LELO_GR03_1.x7.x10.D LELO_GR03_1.x10.CK VGND sky130_fd_pr__nfet_01v8 ad=0.848 pd=4.26 as=0.528 ps=2.26 w=1.6 l=0.94
X69 LELO_GR03_1.x1.x18.S LELO_GR03_1.x7.PWRUP_N_1V8 VDPWR VDPWR sky130_fd_pr__pfet_01v8 ad=0.8352 pd=3.46 as=1.4112 ps=6.74 w=2.88 l=0.22
X70 LELO_GR03_1.x7.VB_N a_12178_2046# VGND sky130_fd_pr__res_high_po w=0.36 l=7.36
X71 LELO_GR03_1.x12<1>.A LELO_GR03_1.x7.PWRUP_N_1V8 VGND VGND sky130_fd_pr__nfet_01v8 ad=0.528 pd=2.26 as=0.848 ps=4.26 w=1.6 l=0.94
X72 LELO_GR03_1.x1.x14.D a_5720_15234# VGND sky130_fd_pr__res_high_po w=0.36 l=7.36
X73 LELO_GR03_1.x1.x18.S LELO_GR03_1.x1.x21.OUT LELO_GR03_1.x1.x9.D VDPWR sky130_fd_pr__pfet_01v8 ad=0.5088 pd=2.98 as=0.3168 ps=1.62 w=0.96 l=0.94
X74 LELO_GR03_1.x1.x21.x6.G a_3500_8957# VGND sky130_fd_pr__res_high_po w=0.36 l=7.36
X75 VGND VGND VGND VGND sky130_fd_pr__nfet_01v8 ad=0.528 pd=2.26 as=199.33521 ps=1.08756k w=1.6 l=0.94
X76 LELO_GR03_1.x1.x21.OUT LELO_GR03_1.x1.x21.x6.G LELO_GR03_1.x1.x21.x6.S VGND sky130_fd_pr__nfet_01v8 ad=0.528 pd=2.26 as=0.848 ps=4.26 w=1.6 l=0.94
X77 LELO_GR03_1.x7.x20.G LELO_GR03_1.x7.x21.G LELO_GR03_1.x7.x21.S VDPWR sky130_fd_pr__pfet_01v8 ad=0.528 pd=2.26 as=0.848 ps=4.26 w=1.6 l=0.94
X78 LELO_GR03_1.x1.x21.x3<1>.D LELO_GR03_1.x1.XQ2<3>.Emitter LELO_GR03_1.x1.x21.x4.G VDPWR sky130_fd_pr__pfet_01v8_lvt ad=0.848 pd=4.26 as=0.528 ps=2.26 w=1.6 l=0.94
X79 a_13258_11042# a_13042_9122# VGND sky130_fd_pr__res_high_po w=0.36 l=7.36
X80 VGND VGND VGND VGND sky130_fd_pr__nfet_01v8 ad=0.468 pd=2.84 as=0 ps=0 w=0.9 l=0.16
X81 VDPWR VDPWR VDPWR VDPWR sky130_fd_pr__pfet_01v8 ad=0.848 pd=4.26 as=46.8984 ps=233.08 w=1.6 l=0.94
X82 LELO_GR03_1.x1.x21.x3<1>.S LELO_GR03_1.x1.VB_P LELO_GR03_1.x1.x21.OUT VDPWR sky130_fd_pr__pfet_01v8 ad=0.848 pd=4.26 as=0.528 ps=2.26 w=1.6 l=0.94
X83 VDPWR LELO_GR03_1.x7.PWRUP_N_1V8 LELO_GR03_1.x1.x18.S VDPWR sky130_fd_pr__pfet_01v8 ad=1.4112 pd=6.74 as=0.8352 ps=3.46 w=2.88 l=0.22
X84 a_11962_3966# a_11746_2046# VGND sky130_fd_pr__res_high_po w=0.36 l=7.36
X85 LELO_GR03_1.x10.XA5.A LELO_GR03_1.x10.XA7.C LELO_GR03_1.x10.XA3.MN1.S VGND sky130_fd_pr__nfet_01v8 ad=0.468 pd=2.84 as=0.288 ps=1.54 w=0.9 l=0.16
X86 LELO_GR03_1.x7.x8.S LELO_GR03_1.x7.x6.G LELO_GR03_1.x7.x6.G VGND sky130_fd_pr__nfet_01v8 ad=0.848 pd=4.26 as=0.528 ps=2.26 w=1.6 l=0.94
X87 LELO_GR03_1.x1.x15.G LELO_GR03_1.x1.x15.G VGND VGND sky130_fd_pr__nfet_01v8 ad=0.528 pd=2.26 as=0.848 ps=4.26 w=1.6 l=0.94
X88 a_13258_7464# a_13042_5544# VGND sky130_fd_pr__res_high_po w=0.36 l=7.36
X89 LELO_GR03_1.x7.x21.S LELO_GR03_1.x7.x20.G LELO_GR03_1.x7.x21.G VDPWR sky130_fd_pr__pfet_01v8 ad=0.848 pd=4.26 as=0.528 ps=2.26 w=1.6 l=0.94
X90 a_12826_11042# a_12610_9122# VGND sky130_fd_pr__res_high_po w=0.36 l=7.36
X91 a_11962_3966# a_12178_2046# VGND sky130_fd_pr__res_high_po w=0.36 l=7.36
X92 VGND LELO_GR03_1.x7.PWRUP_1V8 LELO_GR03_1.x7.x8.S VGND sky130_fd_pr__nfet_01v8 ad=1.4112 pd=6.74 as=0.8352 ps=3.46 w=2.88 l=0.22
X93 LELO_GR03_1.x1.VB_P LELO_GR03_1.x1.VB_P LELO_GR03_1.BIAS_CIRCUIT2_0.xc4.D VDPWR sky130_fd_pr__pfet_01v8 ad=0.528 pd=2.26 as=0.848 ps=4.26 w=1.6 l=0.94
X94 LELO_GR03_1.x7.PWRUP_1V8 LELO_GR03_1.x7.PWRUP_N_1V8 VGND VGND sky130_fd_pr__nfet_01v8 ad=0.468 pd=2.84 as=0.468 ps=2.84 w=0.9 l=0.16
X95 VGND LELO_GR03_1.x7.PWRUP_1V8 LELO_GR03_1.x1.x21.x6.S VGND sky130_fd_pr__nfet_01v8 ad=1.4112 pd=6.74 as=0.8352 ps=3.46 w=2.88 l=0.22
X96 LELO_GR03_1.x7.x21.G LELO_GR03_1.x7.x20.G LELO_GR03_1.x7.x21.S VDPWR sky130_fd_pr__pfet_01v8 ad=0.528 pd=2.26 as=0.848 ps=4.26 w=1.6 l=0.94
X97 LELO_GR03_1.x10.XA6.MN1.S LELO_GR03_1.x10.XA6.A VGND VGND sky130_fd_pr__nfet_01v8 ad=0.288 pd=1.54 as=0.468 ps=2.84 w=0.9 l=0.16
X98 LELO_GR03_1.x7.INN a_7660_15234# VGND sky130_fd_pr__res_high_po w=0.36 l=7.36
X99 a_12826_7464# a_12610_5544# VGND sky130_fd_pr__res_high_po w=0.36 l=7.36
X100 LELO_GR03_1.x1.x18.S LELO_GR03_1.x1.x21.OUT LELO_GR03_1.x1.x11.D VDPWR sky130_fd_pr__pfet_01v8 ad=0.5088 pd=2.98 as=0.3168 ps=1.62 w=0.96 l=0.94
X101 LELO_GR03_1.x7.x7<2>.S LELO_GR03_1.x7.VB_N LELO_GR03_1.x7.x8.S VGND sky130_fd_pr__nfet_01v8 ad=0.528 pd=2.26 as=0.848 ps=4.26 w=1.6 l=0.94
X102 VDPWR LELO_GR03_1.x7.PWRUP_N_1V8 LELO_GR03_1.x7.x21.S VDPWR sky130_fd_pr__pfet_01v8 ad=1.4112 pd=6.74 as=0.8352 ps=3.46 w=2.88 l=0.22
X103 LELO_GR03_1.BIAS_CIRCUIT2_0.xa5.N a_11746_2046# VGND sky130_fd_pr__res_high_po w=0.36 l=7.36
X104 LELO_GR03_1.x7.x21.G LELO_GR03_1.x12<1>.A LELO_GR03_1.x7.x7<2>.S VGND sky130_fd_pr__nfet_01v8 ad=0.528 pd=2.26 as=0.848 ps=4.26 w=1.6 l=0.94
X105 LELO_GR03_1.x1.x21.x3<1>.S LELO_GR03_1.x7.PWRUP_N_1V8 VDPWR VDPWR sky130_fd_pr__pfet_01v8 ad=0.8352 pd=3.46 as=1.4112 ps=6.74 w=2.88 l=0.22
R2 uio_oe<6> JNWTR_TIEL_CV_0.Y sky130_fd_pr__res_generic_m4 w=0.3 l=0.3
X106 VDPWR VDPWR VDPWR VDPWR sky130_fd_pr__pfet_01v8 ad=0.468 pd=2.84 as=0 ps=0 w=0.9 l=0.16
X107 LELO_GR03_1.x10.CK LELO_GR03_1.x7.x10.D LELO_GR03_1.x7.x21.S VDPWR sky130_fd_pr__pfet_01v8 ad=0.528 pd=2.26 as=0.848 ps=4.26 w=1.6 l=0.94
X108 LELO_GR03_1.x1.x21.x6.G LELO_GR03_1.x1.x21.INP LELO_GR03_1.x1.x21.x3<1>.D VDPWR sky130_fd_pr__pfet_01v8_lvt ad=0.528 pd=2.26 as=0.848 ps=4.26 w=1.6 l=0.94
X109 LELO_GR03_1.x7.x7<2>.S LELO_GR03_1.x12<1>.A LELO_GR03_1.x7.x21.G VGND sky130_fd_pr__nfet_01v8 ad=0.848 pd=4.26 as=0.528 ps=2.26 w=1.6 l=0.94
X110 VDPWR VDPWR VDPWR VDPWR sky130_fd_pr__pfet_01v8 ad=0.528 pd=2.26 as=0 ps=0 w=1.6 l=0.94
X111 LELO_GR03_1.x1.x21.x3<1>.D LELO_GR03_1.x1.VB_P LELO_GR03_1.x1.x21.x3<1>.S VDPWR sky130_fd_pr__pfet_01v8 ad=0.528 pd=2.26 as=0.848 ps=4.26 w=1.6 l=0.94
X112 LELO_GR03_1.x10.XA5.A LELO_GR03_1.x10.XA7.CN LELO_GR03_1.x10.XA4.MN1.S VGND sky130_fd_pr__nfet_01v8 ad=0.468 pd=2.84 as=0.288 ps=1.54 w=0.9 l=0.16
X113 VGND VGND LELO_GR03_1.x1.XQ2.Emitter sky130_fd_pr__pnp_05v5_W3p40L3p40
**devattr s=462400,2720
X114 a_14554_11042# a_14770_9122# VGND sky130_fd_pr__res_high_po w=0.36 l=7.36
X115 LELO_GR03_1.x10.XA3.MP1.S LELO_GR03_1.x10.D VDPWR VDPWR sky130_fd_pr__pfet_01v8 ad=0.288 pd=1.54 as=0.468 ps=2.84 w=0.9 l=0.16
X116 VGND VGND LELO_GR03_1.x1.XQ2.Emitter sky130_fd_pr__pnp_05v5_W3p40L3p40
**devattr s=462400,2720
X117 LELO_GR03_1.x1.x21.x6.S LELO_GR03_1.x1.x21.x4.G LELO_GR03_1.x1.x21.x4.G VGND sky130_fd_pr__nfet_01v8 ad=0.848 pd=4.26 as=0.528 ps=2.26 w=1.6 l=0.94
X118 uo_out<0> LELO_GR03_1.x10.D VGND VGND sky130_fd_pr__nfet_01v8 ad=0.468 pd=2.84 as=0.468 ps=2.84 w=0.9 l=0.16
X119 LELO_GR03_1.x7.x21.S LELO_GR03_1.x7.x20.G LELO_GR03_1.x7.x10.D VDPWR sky130_fd_pr__pfet_01v8 ad=0.848 pd=4.26 as=0.528 ps=2.26 w=1.6 l=0.94
X120 VGND VGND LELO_GR03_1.x1.XQ2.Emitter sky130_fd_pr__pnp_05v5_W3p40L3p40
**devattr s=462400,2720
X121 LELO_GR03_1.x1.x17.D LELO_GR03_1.x1.x21.OUT LELO_GR03_1.x1.x18.S VDPWR sky130_fd_pr__pfet_01v8 ad=0.3168 pd=1.62 as=0.5088 ps=2.98 w=0.96 l=0.94
X122 a_14554_7464# a_14770_5544# VGND sky130_fd_pr__res_high_po w=0.36 l=7.36
X123 LELO_GR03_1.x1.x21.OUT LELO_GR03_1.x1.x18.S sky130_fd_pr__cap_mim_m3_1 l=5 w=5
X124 LELO_GR03_1.x12<1>.A LELO_GR03_1.x1.x21.OUT LELO_GR03_1.x1.x9.D VDPWR sky130_fd_pr__pfet_01v8 ad=0.3168 pd=1.62 as=0.5088 ps=2.98 w=0.96 l=0.94
X125 VDPWR VDPWR VDPWR VDPWR sky130_fd_pr__pfet_01v8 ad=0.848 pd=4.26 as=0 ps=0 w=1.6 l=0.94
X126 LELO_GR03_1.x1.x21.x3<1>.S LELO_GR03_1.x1.VB_P LELO_GR03_1.x1.x21.x3<1>.D VDPWR sky130_fd_pr__pfet_01v8 ad=0.848 pd=4.26 as=0.528 ps=2.26 w=1.6 l=0.94
X127 LELO_GR03_1.x10.XA7.MN0.S VDPWR VGND VGND sky130_fd_pr__nfet_01v8 ad=0.288 pd=1.54 as=0.468 ps=2.84 w=0.9 l=0.16
X128 VGND VGND LELO_GR03_1.x1.XQ2.Emitter sky130_fd_pr__pnp_05v5_W3p40L3p40
**devattr s=462400,2720
X129 VDPWR LELO_GR03_1.x7.PWRUP_N_1V8 LELO_GR03_1.BIAS_CIRCUIT2_0.xb7.D VDPWR sky130_fd_pr__pfet_01v8 ad=1.4112 pd=6.74 as=0.8352 ps=3.46 w=2.88 l=0.22
X130 VGND VGND LELO_GR03_1.x1.XQ2.Emitter sky130_fd_pr__pnp_05v5_W3p40L3p40
**devattr s=462400,2720
X131 VGND VGND LELO_GR03_1.x1.XQ2.Emitter sky130_fd_pr__pnp_05v5_W3p40L3p40
**devattr s=462400,2720
X132 VGND VGND LELO_GR03_1.x1.XQ2.Emitter sky130_fd_pr__pnp_05v5_W3p40L3p40
**devattr s=462400,2720
X133 a_5504_17154# a_5720_15234# VGND sky130_fd_pr__res_high_po w=0.36 l=7.36
X134 a_14554_11042# a_14338_9122# VGND sky130_fd_pr__res_high_po w=0.36 l=7.36
X135 VGND VGND LELO_GR03_1.x1.XQ2.Emitter sky130_fd_pr__pnp_05v5_W3p40L3p40
**devattr s=462400,2720
X136 LELO_GR03_1.x7.x21.S LELO_GR03_1.x7.x20.G LELO_GR03_1.x7.x21.G VDPWR sky130_fd_pr__pfet_01v8 ad=0.848 pd=4.26 as=0.528 ps=2.26 w=1.6 l=0.94
X137 VDPWR VDPWR LELO_GR03_1.x10.XA7.C VDPWR sky130_fd_pr__pfet_01v8 ad=0.468 pd=2.84 as=0.288 ps=1.54 w=0.9 l=0.16
X138 LELO_GR03_1.x7.x8.S LELO_GR03_1.x7.PWRUP_1V8 VGND VGND sky130_fd_pr__nfet_01v8 ad=0.8352 pd=3.46 as=1.4112 ps=6.74 w=2.88 l=0.22
X139 LELO_GR03_1.x1.x21.INP a_7228_15234# VGND sky130_fd_pr__res_high_po w=0.36 l=7.36
X140 a_14554_7464# a_14338_5544# VGND sky130_fd_pr__res_high_po w=0.36 l=7.36
X141 LELO_GR03_1.x7.x21.S LELO_GR03_1.x7.x21.G LELO_GR03_1.x7.x21.G VDPWR sky130_fd_pr__pfet_01v8 ad=0.848 pd=4.26 as=0.528 ps=2.26 w=1.6 l=0.94
X142 LELO_GR03_1.BIAS_CIRCUIT2_0.xc2.S LELO_GR03_1.x7.PWRUP_1V8 VGND VGND sky130_fd_pr__nfet_01v8 ad=0.8352 pd=3.46 as=1.4112 ps=6.74 w=2.88 l=0.22
X143 LELO_GR03_1.x1.x21.OUT LELO_GR03_1.x1.x21.x11<1>.A sky130_fd_pr__cap_mim_m3_1 l=5 w=5
X144 VGND VGND LELO_GR03_1.x1.XQ2.Emitter sky130_fd_pr__pnp_05v5_W3p40L3p40
**devattr s=462400,2720
X145 LELO_GR03_1.x1.x21.x4.G LELO_GR03_1.x1.XQ2<3>.Emitter LELO_GR03_1.x1.x21.x3<1>.D VDPWR sky130_fd_pr__pfet_01v8_lvt ad=0.528 pd=2.26 as=0.848 ps=4.26 w=1.6 l=0.94
X146 LELO_GR03_1.x7.x6.G LELO_GR03_1.x7.x21.G LELO_GR03_1.x7.x21.S VDPWR sky130_fd_pr__pfet_01v8 ad=0.528 pd=2.26 as=0.848 ps=4.26 w=1.6 l=0.94
X147 LELO_GR03_1.x7.x7<2>.S LELO_GR03_1.x7.VB_N LELO_GR03_1.x7.x8.S VGND sky130_fd_pr__nfet_01v8 ad=0.528 pd=2.26 as=0.848 ps=4.26 w=1.6 l=0.94
X148 LELO_GR03_1.x7.INN LELO_GR03_1.x1.x21.OUT LELO_GR03_1.x1.x11.D VDPWR sky130_fd_pr__pfet_01v8 ad=0.3168 pd=1.62 as=0.5088 ps=2.98 w=0.96 l=0.94
X149 VDPWR LELO_GR03_1.x7.PWRUP_N_1V8 LELO_GR03_1.x1.x21.x3<1>.S VDPWR sky130_fd_pr__pfet_01v8 ad=1.4112 pd=6.74 as=0.8352 ps=3.46 w=2.88 l=0.22
X150 LELO_GR03_1.x10.XA4.MP1.S LELO_GR03_1.x10.XA6.A VDPWR VDPWR sky130_fd_pr__pfet_01v8 ad=0.288 pd=1.54 as=0.468 ps=2.84 w=0.9 l=0.16
X151 VGND LELO_GR03_1.x7.PWRUP_1V8 LELO_GR03_1.x1.x21.x6.S VGND sky130_fd_pr__nfet_01v8 ad=1.4112 pd=6.74 as=0.8352 ps=3.46 w=2.88 l=0.22
X152 a_14122_11042# a_14338_9122# VGND sky130_fd_pr__res_high_po w=0.36 l=7.36
X153 LELO_GR03_1.x7.x21.S LELO_GR03_1.x7.x21.G LELO_GR03_1.x7.x20.G VDPWR sky130_fd_pr__pfet_01v8 ad=0.848 pd=4.26 as=0.528 ps=2.26 w=1.6 l=0.94
X154 LELO_GR03_1.x7.x20.G LELO_GR03_1.x7.x20.G LELO_GR03_1.x7.x21.S VDPWR sky130_fd_pr__pfet_01v8 ad=0.528 pd=2.26 as=0.848 ps=4.26 w=1.6 l=0.94
X155 VDPWR VDPWR VDPWR VDPWR sky130_fd_pr__pfet_01v8 ad=0.468 pd=2.84 as=0 ps=0 w=0.9 l=0.16
X156 JNWTR_TIEL_CV_0.Y JNWTR_TIEL_CV_0.MP0.G VGND VGND sky130_fd_pr__nfet_01v8 ad=0.468 pd=2.84 as=0.468 ps=2.84 w=0.9 l=0.16
X157 a_7444_17154# a_7660_15234# VGND sky130_fd_pr__res_high_po w=0.36 l=7.36
X158 a_14122_7464# a_14338_5544# VGND sky130_fd_pr__res_high_po w=0.36 l=7.36
X159 LELO_GR03_1.x7.x20.G LELO_GR03_1.x7.x21.G LELO_GR03_1.x7.x21.S VDPWR sky130_fd_pr__pfet_01v8 ad=0.528 pd=2.26 as=0.848 ps=4.26 w=1.6 l=0.94
X160 LELO_GR03_1.x1.x21.x3<1>.D LELO_GR03_1.x1.x21.INP LELO_GR03_1.x1.x21.x6.G VDPWR sky130_fd_pr__pfet_01v8_lvt ad=0.848 pd=4.26 as=0.528 ps=2.26 w=1.6 l=0.94
X161 LELO_GR03_1.x7.x8.S LELO_GR03_1.x7.x6.G LELO_GR03_1.x7.x10.D VGND sky130_fd_pr__nfet_01v8 ad=0.848 pd=4.26 as=0.528 ps=2.26 w=1.6 l=0.94
X162 LELO_GR03_1.x7.x7<2>.S LELO_GR03_1.x12<1>.A LELO_GR03_1.x7.x21.G VGND sky130_fd_pr__nfet_01v8 ad=0.848 pd=4.26 as=0.528 ps=2.26 w=1.6 l=0.94
X163 a_3284_10877# a_3500_8957# VGND sky130_fd_pr__res_high_po w=0.36 l=7.36
X164 a_13690_11042# a_13906_9122# VGND sky130_fd_pr__res_high_po w=0.36 l=7.36
X165 LELO_GR03_1.x1.x21.OUT LELO_GR03_1.x1.x18.S sky130_fd_pr__cap_mim_m3_1 l=5 w=5
X166 LELO_GR03_1.x1.x17.D LELO_GR03_1.x1.x21.OUT LELO_GR03_1.x1.x14.D VDPWR sky130_fd_pr__pfet_01v8 ad=0.5088 pd=2.98 as=0.3168 ps=1.62 w=0.96 l=0.94
X167 a_12826_11042# a_13042_9122# VGND sky130_fd_pr__res_high_po w=0.36 l=7.36
X168 LELO_GR03_1.x7.x20.G LELO_GR03_1.x7.INN LELO_GR03_1.x7.x7<2>.S VGND sky130_fd_pr__nfet_01v8 ad=0.528 pd=2.26 as=0.848 ps=4.26 w=1.6 l=0.94
X169 a_13690_7464# a_13906_5544# VGND sky130_fd_pr__res_high_po w=0.36 l=7.36
X170 VGND LELO_GR03_1.x12<1>.A sky130_fd_pr__cap_mim_m3_1 l=5 w=5
X171 LELO_GR03_1.x10.XA6.A LELO_GR03_1.x10.XA5.A VDPWR VDPWR sky130_fd_pr__pfet_01v8 ad=0.468 pd=2.84 as=0.468 ps=2.84 w=0.9 l=0.16
X172 VGND LELO_GR03_1.x7.PWRUP_1V8 LELO_GR03_1.BIAS_CIRCUIT2_0.xb6.S VGND sky130_fd_pr__nfet_01v8 ad=1.4112 pd=6.74 as=0.8352 ps=3.46 w=2.88 l=0.22
X173 LELO_GR03_1.BIAS_CIRCUIT2_0.xb7.D LELO_GR03_1.x7.PWRUP_N_1V8 VDPWR VDPWR sky130_fd_pr__pfet_01v8 ad=0.8352 pd=3.46 as=1.4112 ps=6.74 w=2.88 l=0.22
X174 a_12826_7464# a_13042_5544# VGND sky130_fd_pr__res_high_po w=0.36 l=7.36
X175 LELO_GR03_1.x1.x21.OUT LELO_GR03_1.x1.x18.G LELO_GR03_1.x1.x18.S VDPWR sky130_fd_pr__pfet_01v8 ad=0.528 pd=2.26 as=0.848 ps=4.26 w=1.6 l=0.94
X176 LELO_GR03_1.x1.x21.OUT LELO_GR03_1.x1.x21.OUT VGND VGND sky130_fd_pr__nfet_01v8 ad=0.528 pd=2.26 as=0.848 ps=4.26 w=1.6 l=0.94
R3 uio_oe<5> JNWTR_TIEL_CV_0.Y sky130_fd_pr__res_generic_m4 w=0.3 l=0.3
X177 LELO_GR03_1.x7.VB_N LELO_GR03_1.x7.VB_N LELO_GR03_1.BIAS_CIRCUIT2_0.xc2.S VGND sky130_fd_pr__nfet_01v8 ad=0.528 pd=2.26 as=0.848 ps=4.26 w=1.6 l=0.94
X178 LELO_GR03_1.x1.x18.G LELO_GR03_1.x1.x21.OUT LELO_GR03_1.x1.x15.G VGND sky130_fd_pr__nfet_01v8 ad=0.528 pd=2.26 as=0.848 ps=4.26 w=1.6 l=0.94
X179 a_12394_11042# a_12610_9122# VGND sky130_fd_pr__res_high_po w=0.36 l=7.36
X180 LELO_GR03_1.x12<1>.A LELO_GR03_1.x10.CK VGND VGND sky130_fd_pr__nfet_01v8 ad=0.528 pd=2.26 as=0.848 ps=4.26 w=1.6 l=0.94
X181 VGND LELO_GR03_1.x12<1>.A sky130_fd_pr__cap_mim_m3_1 l=5 w=5
X182 VGND VGND VGND VGND sky130_fd_pr__nfet_01v8 ad=0.468 pd=2.84 as=0 ps=0 w=0.9 l=0.16
X183 LELO_GR03_1.x7.x7<2>.S LELO_GR03_1.x7.INN LELO_GR03_1.x7.x20.G VGND sky130_fd_pr__nfet_01v8 ad=0.848 pd=4.26 as=0.528 ps=2.26 w=1.6 l=0.94
X184 LELO_GR03_1.x7.x20.G LELO_GR03_1.x7.INN LELO_GR03_1.x7.x7<2>.S VGND sky130_fd_pr__nfet_01v8 ad=0.528 pd=2.26 as=0.848 ps=4.26 w=1.6 l=0.94
X185 LELO_GR03_1.x10.D LELO_GR03_1.x10.XA7.CN LELO_GR03_1.x10.XA7.MP1.S VDPWR sky130_fd_pr__pfet_01v8 ad=0.468 pd=2.84 as=0.288 ps=1.54 w=0.9 l=0.16
X186 a_12394_7464# a_12610_5544# VGND sky130_fd_pr__res_high_po w=0.36 l=7.36
X187 LELO_GR03_1.x1.x21.x6.G LELO_GR03_1.x1.x21.x4.G LELO_GR03_1.x1.x21.x6.S VGND sky130_fd_pr__nfet_01v8 ad=0.528 pd=2.26 as=0.848 ps=4.26 w=1.6 l=0.94
X188 LELO_GR03_1.x1.x21.OUT LELO_GR03_1.x1.x21.x11<1>.A sky130_fd_pr__cap_mim_m3_1 l=5 w=5
X189 LELO_GR03_1.x1.x18.S LELO_GR03_1.x1.x18.G LELO_GR03_1.x1.x18.G VDPWR sky130_fd_pr__pfet_01v8 ad=0.848 pd=4.26 as=0.528 ps=2.26 w=1.6 l=0.94
X190 VDPWR LELO_GR03_1.x7.PWRUP_N_1V8 LELO_GR03_1.x7.x21.S VDPWR sky130_fd_pr__pfet_01v8 ad=1.4112 pd=6.74 as=0.8352 ps=3.46 w=2.88 l=0.22
X191 LELO_GR03_1.x1.x18.S LELO_GR03_1.x7.PWRUP_N_1V8 VDPWR VDPWR sky130_fd_pr__pfet_01v8 ad=0.8352 pd=3.46 as=1.4112 ps=6.74 w=2.88 l=0.22
X192 LELO_GR03_1.x1.x21.x3<1>.S LELO_GR03_1.x7.PWRUP_N_1V8 VDPWR VDPWR sky130_fd_pr__pfet_01v8 ad=0.8352 pd=3.46 as=1.4112 ps=6.74 w=2.88 l=0.22
X193 LELO_GR03_1.x10.XA3.MN1.S LELO_GR03_1.x10.D VGND VGND sky130_fd_pr__nfet_01v8 ad=0.288 pd=1.54 as=0.468 ps=2.84 w=0.9 l=0.16
X194 LELO_GR03_1.x1.x21.x4.G LELO_GR03_1.x1.XQ2<3>.Emitter LELO_GR03_1.x1.x21.x3<1>.D VDPWR sky130_fd_pr__pfet_01v8_lvt ad=0.528 pd=2.26 as=0.848 ps=4.26 w=1.6 l=0.94
R4 uio_oe<4> JNWTR_TIEL_CV_0.Y sky130_fd_pr__res_generic_m4 w=0.3 l=0.3
X195 LELO_GR03_1.x1.x21.x3<1>.D LELO_GR03_1.x1.x21.INP LELO_GR03_1.x1.x21.x6.G VDPWR sky130_fd_pr__pfet_01v8_lvt ad=0.848 pd=4.26 as=0.528 ps=2.26 w=1.6 l=0.94
X196 LELO_GR03_1.x7.x8.S LELO_GR03_1.x7.PWRUP_1V8 VGND VGND sky130_fd_pr__nfet_01v8 ad=0.8352 pd=3.46 as=1.4112 ps=6.74 w=2.88 l=0.22
X197 VGND LELO_GR03_1.x7.PWRUP_N_1V8 LELO_GR03_1.x12<1>.A VGND sky130_fd_pr__nfet_01v8 ad=0.848 pd=4.26 as=0.528 ps=2.26 w=1.6 l=0.94
X198 VGND VGND VGND VGND sky130_fd_pr__nfet_01v8 ad=0.848 pd=4.26 as=0 ps=0 w=1.6 l=0.94
X199 LELO_GR03_1.x1.x21.x6.S LELO_GR03_1.x1.x21.x6.G LELO_GR03_1.x1.x21.OUT VGND sky130_fd_pr__nfet_01v8 ad=0.848 pd=4.26 as=0.528 ps=2.26 w=1.6 l=0.94
X200 LELO_GR03_1.x1.x21.x6.S LELO_GR03_1.x7.PWRUP_1V8 VGND VGND sky130_fd_pr__nfet_01v8 ad=0.8352 pd=3.46 as=1.4112 ps=6.74 w=2.88 l=0.22
X201 LELO_GR03_1.x7.x21.S LELO_GR03_1.x7.x21.G LELO_GR03_1.x7.x20.G VDPWR sky130_fd_pr__pfet_01v8 ad=0.848 pd=4.26 as=0.528 ps=2.26 w=1.6 l=0.94
X202 LELO_GR03_1.x10.D LELO_GR03_1.x10.XA7.C LELO_GR03_1.x10.XA6.MP1.S VDPWR sky130_fd_pr__pfet_01v8 ad=0.468 pd=2.84 as=0.288 ps=1.54 w=0.9 l=0.16
X203 LELO_GR03_1.x7.x21.S LELO_GR03_1.x7.PWRUP_N_1V8 VDPWR VDPWR sky130_fd_pr__pfet_01v8 ad=0.8352 pd=3.46 as=1.4112 ps=6.74 w=2.88 l=0.22
X204 VGND VGND LELO_GR03_1.x1.XQ2.Emitter sky130_fd_pr__pnp_05v5_W3p40L3p40
**devattr s=462400,2720
X205 VGND VGND LELO_GR03_1.x1.XQ2.Emitter sky130_fd_pr__pnp_05v5_W3p40L3p40
**devattr s=462400,2720
X206 VGND LELO_GR03_1.x1.x15.G LELO_GR03_1.x1.x15.G VGND sky130_fd_pr__nfet_01v8 ad=0.848 pd=4.26 as=0.528 ps=2.26 w=1.6 l=0.94
X207 LELO_GR03_1.x10.XA7.C VDPWR LELO_GR03_1.x10.XA1.MN1.S VGND sky130_fd_pr__nfet_01v8 ad=0.468 pd=2.84 as=0.288 ps=1.54 w=0.9 l=0.16
X208 VGND VGND LELO_GR03_1.x1.XQ2.Emitter sky130_fd_pr__pnp_05v5_W3p40L3p40
**devattr s=462400,2720
X209 LELO_GR03_1.x1.VB_P LELO_GR03_1.x7.VB_N LELO_GR03_1.BIAS_CIRCUIT2_0.xb6.S VGND sky130_fd_pr__nfet_01v8 ad=0.528 pd=2.26 as=0.848 ps=4.26 w=1.6 l=0.94
X210 VGND LELO_GR03_1.x7.PWRUP_1V8 LELO_GR03_1.x7.x8.S VGND sky130_fd_pr__nfet_01v8 ad=1.4112 pd=6.74 as=0.8352 ps=3.46 w=2.88 l=0.22
X211 VGND VGND LELO_GR03_1.x1.XQ2.Emitter sky130_fd_pr__pnp_05v5_W3p40L3p40
**devattr s=462400,2720
X212 VDPWR LELO_GR03_1.x7.PWRUP_N_1V8 LELO_GR03_1.x1.x18.S VDPWR sky130_fd_pr__pfet_01v8 ad=1.4112 pd=6.74 as=0.8352 ps=3.46 w=2.88 l=0.22
X213 LELO_GR03_1.BIAS_CIRCUIT2_0.xc4.D LELO_GR03_1.x1.VB_P LELO_GR03_1.x1.VB_P VDPWR sky130_fd_pr__pfet_01v8 ad=0.848 pd=4.26 as=0.528 ps=2.26 w=1.6 l=0.94
X214 VGND LELO_GR03_1.x7.PWRUP_1V8 LELO_GR03_1.x1.x21.x6.S VGND sky130_fd_pr__nfet_01v8 ad=1.4112 pd=6.74 as=0.8352 ps=3.46 w=2.88 l=0.22
X215 LELO_GR03_1.x10.CK LELO_GR03_1.x7.x10.D LELO_GR03_1.x7.x8.S VGND sky130_fd_pr__nfet_01v8 ad=0.528 pd=2.26 as=0.848 ps=4.26 w=1.6 l=0.94
X216 LELO_GR03_1.x7.PWRUP_N_1V8 ui_in<0> VGND VGND sky130_fd_pr__nfet_01v8 ad=0.468 pd=2.84 as=0.468 ps=2.84 w=0.9 l=0.16
X217 VDPWR LELO_GR03_1.x7.PWRUP_N_1V8 LELO_GR03_1.BIAS_CIRCUIT2_0.xc4.D VDPWR sky130_fd_pr__pfet_01v8 ad=1.4112 pd=6.74 as=0.8352 ps=3.46 w=2.88 l=0.22
X218 LELO_GR03_1.x7.x21.S LELO_GR03_1.x7.x20.G LELO_GR03_1.x7.x21.G VDPWR sky130_fd_pr__pfet_01v8 ad=0.848 pd=4.26 as=0.528 ps=2.26 w=1.6 l=0.94
X219 LELO_GR03_1.x1.x9.D LELO_GR03_1.x1.x21.OUT LELO_GR03_1.x1.x18.S VDPWR sky130_fd_pr__pfet_01v8 ad=0.3168 pd=1.62 as=0.5088 ps=2.98 w=0.96 l=0.94
X220 VDPWR LELO_GR03_1.x7.PWRUP_N_1V8 LELO_GR03_1.x7.x21.S VDPWR sky130_fd_pr__pfet_01v8 ad=1.4112 pd=6.74 as=0.8352 ps=3.46 w=2.88 l=0.22
X221 LELO_GR03_1.x10.XA4.MN1.S LELO_GR03_1.x10.XA6.A VGND VGND sky130_fd_pr__nfet_01v8 ad=0.288 pd=1.54 as=0.468 ps=2.84 w=0.9 l=0.16
X222 LELO_GR03_1.x10.XA7.MP1.S uo_out<0> VDPWR VDPWR sky130_fd_pr__pfet_01v8 ad=0.288 pd=1.54 as=0.288 ps=1.54 w=0.9 l=0.16
X223 LELO_GR03_1.x7.x8.S LELO_GR03_1.x7.VB_N LELO_GR03_1.x7.x7<2>.S VGND sky130_fd_pr__nfet_01v8 ad=0.848 pd=4.26 as=0.528 ps=2.26 w=1.6 l=0.94
X224 VGND VGND LELO_GR03_1.x1.XQ2.Emitter sky130_fd_pr__pnp_05v5_W3p40L3p40
**devattr s=462400,2720
X225 VGND VGND LELO_GR03_1.x1.XQ2.Emitter sky130_fd_pr__pnp_05v5_W3p40L3p40
**devattr s=462400,2720
X226 LELO_GR03_1.x1.x21.x4.G LELO_GR03_1.x1.XQ2<3>.Emitter LELO_GR03_1.x1.x21.x3<1>.D VDPWR sky130_fd_pr__pfet_01v8_lvt ad=0.528 pd=2.26 as=0.848 ps=4.26 w=1.6 l=0.94
X227 JNWTR_TIEL_CV_0.MP0.G JNWTR_TIEL_CV_0.MP0.G VDPWR VDPWR sky130_fd_pr__pfet_01v8 ad=0.468 pd=2.84 as=0.468 ps=2.84 w=0.9 l=0.16
X228 VDPWR VDPWR VDPWR VDPWR sky130_fd_pr__pfet_01v8 ad=0.528 pd=2.26 as=0 ps=0 w=1.6 l=0.94
X229 LELO_GR03_1.x1.x21.OUT LELO_GR03_1.x1.VB_P LELO_GR03_1.x1.x21.x3<1>.S VDPWR sky130_fd_pr__pfet_01v8 ad=0.528 pd=2.26 as=0.848 ps=4.26 w=1.6 l=0.94
X230 LELO_GR03_1.x10.XA7.C LELO_GR03_1.x10.CK VDPWR VDPWR sky130_fd_pr__pfet_01v8 ad=0.288 pd=1.54 as=0.468 ps=2.84 w=0.9 l=0.16
X231 LELO_GR03_1.x7.x6.G LELO_GR03_1.x7.x6.G LELO_GR03_1.x7.x8.S VGND sky130_fd_pr__nfet_01v8 ad=0.528 pd=2.26 as=0.848 ps=4.26 w=1.6 l=0.94
X232 LELO_GR03_1.x7.x21.S LELO_GR03_1.x7.x10.D LELO_GR03_1.x10.CK VDPWR sky130_fd_pr__pfet_01v8 ad=0.848 pd=4.26 as=0.528 ps=2.26 w=1.6 l=0.94
X233 LELO_GR03_1.x7.x21.G LELO_GR03_1.x7.x20.G LELO_GR03_1.x7.x21.S VDPWR sky130_fd_pr__pfet_01v8 ad=0.528 pd=2.26 as=0.848 ps=4.26 w=1.6 l=0.94
X234 LELO_GR03_1.x1.x21.x3<1>.D LELO_GR03_1.x1.x21.INP LELO_GR03_1.x1.x21.x6.G VDPWR sky130_fd_pr__pfet_01v8_lvt ad=0.848 pd=4.26 as=0.528 ps=2.26 w=1.6 l=0.94
X235 VDPWR LELO_GR03_1.x7.PWRUP_N_1V8 LELO_GR03_1.x1.x18.S VDPWR sky130_fd_pr__pfet_01v8 ad=1.4112 pd=6.74 as=0.8352 ps=3.46 w=2.88 l=0.22
X236 a_14122_11042# a_13906_9122# VGND sky130_fd_pr__res_high_po w=0.36 l=7.36
X237 LELO_GR03_1.x1.x21.INP a_10188_5354# VGND sky130_fd_pr__res_high_po w=0.36 l=7.36
X238 VDPWR VDPWR VDPWR VDPWR sky130_fd_pr__pfet_01v8 ad=0.848 pd=4.26 as=0 ps=0 w=1.6 l=0.94
X239 LELO_GR03_1.x1.x21.x3<1>.S LELO_GR03_1.x1.VB_P LELO_GR03_1.x1.x21.x3<1>.D VDPWR sky130_fd_pr__pfet_01v8 ad=0.848 pd=4.26 as=0.528 ps=2.26 w=1.6 l=0.94
R5 uio_oe<0> JNWTR_TIEL_CV_0.Y sky130_fd_pr__res_generic_m4 w=0.3 l=0.3
R6 uio_oe<3> JNWTR_TIEL_CV_0.Y sky130_fd_pr__res_generic_m4 w=0.3 l=0.3
X240 LELO_GR03_1.x10.XA6.A LELO_GR03_1.x10.XA5.A VGND VGND sky130_fd_pr__nfet_01v8 ad=0.468 pd=2.84 as=0.468 ps=2.84 w=0.9 l=0.16
X241 LELO_GR03_1.x7.x7<2>.S LELO_GR03_1.x12<1>.A LELO_GR03_1.x7.x21.G VGND sky130_fd_pr__nfet_01v8 ad=0.848 pd=4.26 as=0.528 ps=2.26 w=1.6 l=0.94
X242 LELO_GR03_1.x7.x21.G LELO_GR03_1.x12<1>.A LELO_GR03_1.x7.x7<2>.S VGND sky130_fd_pr__nfet_01v8 ad=0.528 pd=2.26 as=0.848 ps=4.26 w=1.6 l=0.94
X243 LELO_GR03_1.x1.x11.D LELO_GR03_1.x1.x21.OUT LELO_GR03_1.x1.x18.S VDPWR sky130_fd_pr__pfet_01v8 ad=0.3168 pd=1.62 as=0.5088 ps=2.98 w=0.96 l=0.94
X244 a_14122_7464# a_13906_5544# VGND sky130_fd_pr__res_high_po w=0.36 l=7.36
X245 a_3284_10877# a_3068_8957# VGND sky130_fd_pr__res_high_po w=0.36 l=7.36
X246 LELO_GR03_1.x1.x18.S LELO_GR03_1.x1.x21.OUT LELO_GR03_1.x1.x17.D VDPWR sky130_fd_pr__pfet_01v8 ad=0.5088 pd=2.98 as=0.3168 ps=1.62 w=0.96 l=0.94
X247 LELO_GR03_1.x10.D LELO_GR03_1.x10.XA7.C LELO_GR03_1.x10.XA7.MP1.S VGND sky130_fd_pr__nfet_01v8 ad=0.468 pd=2.84 as=0.288 ps=1.54 w=0.9 l=0.16
X248 LELO_GR03_1.x7.PWRUP_1V8 LELO_GR03_1.x7.PWRUP_N_1V8 VDPWR VDPWR sky130_fd_pr__pfet_01v8 ad=0.468 pd=2.84 as=0.468 ps=2.84 w=0.9 l=0.16
X249 LELO_GR03_1.x1.x21.x6.S LELO_GR03_1.x7.PWRUP_1V8 VGND VGND sky130_fd_pr__nfet_01v8 ad=0.8352 pd=3.46 as=1.4112 ps=6.74 w=2.88 l=0.22
X250 LELO_GR03_1.BIAS_CIRCUIT2_0.xc4.D LELO_GR03_1.x7.PWRUP_N_1V8 VDPWR VDPWR sky130_fd_pr__pfet_01v8 ad=0.8352 pd=3.46 as=1.4112 ps=6.74 w=2.88 l=0.22
X251 VGND LELO_GR03_1.x12<1>.A sky130_fd_pr__cap_mim_m3_1 l=5 w=5
X252 a_12394_11042# a_12178_9122# VGND sky130_fd_pr__res_high_po w=0.36 l=7.36
X253 a_5504_17154# a_5288_15234# VGND sky130_fd_pr__res_high_po w=0.36 l=7.36
X254 LELO_GR03_1.x1.x9.D LELO_GR03_1.x1.x21.OUT LELO_GR03_1.x12<1>.A VDPWR sky130_fd_pr__pfet_01v8 ad=0.5088 pd=2.98 as=0.3168 ps=1.62 w=0.96 l=0.94
X255 LELO_GR03_1.x1.x21.x11<1>.A a_3068_8957# VGND sky130_fd_pr__res_high_po w=0.36 l=7.36
R7 uio_oe<7> JNWTR_TIEL_CV_0.Y sky130_fd_pr__res_generic_m4 w=0.3 l=0.3
X256 LELO_GR03_1.x1.x21.OUT LELO_GR03_1.x1.x21.x11<1>.A sky130_fd_pr__cap_mim_m3_1 l=5 w=5
X257 LELO_GR03_1.x10.XA7.CN LELO_GR03_1.x10.XA7.C VDPWR VDPWR sky130_fd_pr__pfet_01v8 ad=0.468 pd=2.84 as=0.468 ps=2.84 w=0.9 l=0.16
X258 VDPWR LELO_GR03_1.x7.PWRUP_N_1V8 LELO_GR03_1.x1.x21.x3<1>.S VDPWR sky130_fd_pr__pfet_01v8 ad=1.4112 pd=6.74 as=0.8352 ps=3.46 w=2.88 l=0.22
X259 LELO_GR03_1.x1.x21.x4.G LELO_GR03_1.x1.x21.x4.G LELO_GR03_1.x1.x21.x6.S VGND sky130_fd_pr__nfet_01v8 ad=0.528 pd=2.26 as=0.848 ps=4.26 w=1.6 l=0.94
X260 VGND LELO_GR03_1.x12<1>.A sky130_fd_pr__cap_mim_m3_1 l=5 w=5
X261 LELO_GR03_1.x7.x10.D LELO_GR03_1.x7.x20.G LELO_GR03_1.x7.x21.S VDPWR sky130_fd_pr__pfet_01v8 ad=0.528 pd=2.26 as=0.848 ps=4.26 w=1.6 l=0.94
X262 a_12394_7464# a_12178_5544# VGND sky130_fd_pr__res_high_po w=0.36 l=7.36
X263 VDPWR VDPWR VDPWR VDPWR sky130_fd_pr__pfet_01v8 ad=0.528 pd=2.26 as=0 ps=0 w=1.6 l=0.94
X264 LELO_GR03_1.x1.x21.x3<1>.D LELO_GR03_1.x1.XQ2<3>.Emitter LELO_GR03_1.x1.x21.x4.G VDPWR sky130_fd_pr__pfet_01v8_lvt ad=0.848 pd=4.26 as=0.528 ps=2.26 w=1.6 l=0.94
X265 LELO_GR03_1.x1.x21.x3<1>.D LELO_GR03_1.x1.VB_P LELO_GR03_1.x1.x21.x3<1>.S VDPWR sky130_fd_pr__pfet_01v8 ad=0.528 pd=2.26 as=0.848 ps=4.26 w=1.6 l=0.94
X266 LELO_GR03_1.x7.x21.S LELO_GR03_1.x7.x21.G LELO_GR03_1.x7.x6.G VDPWR sky130_fd_pr__pfet_01v8 ad=0.848 pd=4.26 as=0.528 ps=2.26 w=1.6 l=0.94
X267 LELO_GR03_1.x7.x8.S LELO_GR03_1.x7.VB_N LELO_GR03_1.x7.x7<2>.S VGND sky130_fd_pr__nfet_01v8 ad=0.848 pd=4.26 as=0.528 ps=2.26 w=1.6 l=0.94
X268 VGND ui_in<0> sky130_fd_pr__diode_pw2nd_05v5 perim=1.8e+06 area=2.025e+11
X269 a_11962_11042# a_11746_9122# VGND sky130_fd_pr__res_high_po w=0.36 l=7.36
X270 LELO_GR03_1.BIAS_CIRCUIT2_0.xb6.S LELO_GR03_1.x7.PWRUP_1V8 VGND VGND sky130_fd_pr__nfet_01v8 ad=0.8352 pd=3.46 as=1.4112 ps=6.74 w=2.88 l=0.22
X271 LELO_GR03_1.x10.D LELO_GR03_1.x10.XA7.CN LELO_GR03_1.x10.XA6.MN1.S VGND sky130_fd_pr__nfet_01v8 ad=0.468 pd=2.84 as=0.288 ps=1.54 w=0.9 l=0.16
X272 LELO_GR03_1.x7.x21.S LELO_GR03_1.x7.x20.G LELO_GR03_1.x7.x20.G VDPWR sky130_fd_pr__pfet_01v8 ad=0.848 pd=4.26 as=0.528 ps=2.26 w=1.6 l=0.94
X273 a_11962_11042# a_12178_9122# VGND sky130_fd_pr__res_high_po w=0.36 l=7.36
X274 LELO_GR03_1.x1.x21.OUT LELO_GR03_1.x1.x18.S sky130_fd_pr__cap_mim_m3_1 l=5 w=5
X275 a_11962_7464# a_11746_5544# VGND sky130_fd_pr__res_high_po w=0.36 l=7.36
C0 LELO_GR03_1.x10.XA7.MP1.S a_26988_5288# 0.0183f
C1 LELO_GR03_1.x10.XA7.CN LELO_GR03_1.x10.XA6.MN1.S 0.03056f
C2 LELO_GR03_1.x7.x20.G a_17962_4568# 0.0288f
C3 LELO_GR03_1.x10.XA7.C LELO_GR03_1.x10.XA6.A 0.59031f
C4 uo_out<7> uo_out<6> 0.03102f
C5 a_10452_18060# LELO_GR03_1.x1.x18.S 0.0408f
C6 LELO_GR03_1.x12<1>.A a_14770_5544# 0.01291f
C7 LELO_GR03_1.x1.x21.x6.S a_8392_9507# 0.03837f
C8 LELO_GR03_1.x1.x21.x6.S li_6290_10467# 0.27946f
C9 a_11314_12488# VDPWR 0.42429f
C10 a_23662_2468# VDPWR 0.54085f
C11 LELO_GR03_1.x7.INN a_14770_9122# 0.03724f
C12 LELO_GR03_1.x1.x21.x3<1>.S LELO_GR03_1.x1.x21.x6.S 0.01132f
C13 LELO_GR03_1.x7.PWRUP_1V8 a_5192_9507# 0.1012f
C14 LELO_GR03_1.x1.x21.x6.G a_6292_12883# 0.01298f
C15 a_12412_17180# VDPWR 0.63504f
C16 LELO_GR03_1.x10.CK VDPWR 2.17901f
C17 LELO_GR03_1.x7.x8.S a_19862_2128# 0.04179f
C18 LELO_GR03_1.x7.x10.D a_23662_3268# 0.10492f
C19 LELO_GR03_1.x10.XA7.C LELO_GR03_1.x10.XA6.MN1.S 0.01275f
C20 LELO_GR03_1.x10.XA7.CN a_26988_5288# 0.02572f
C21 LELO_GR03_1.x7.VB_N a_14828_2916# 0.01635f
C22 LELO_GR03_1.BIAS_CIRCUIT2_0.xa5.N VDPWR 0.09013f
C23 a_8932_18060# a_8932_17580# 0.02114f
C24 a_10452_18060# LELO_GR03_1.x7.PWRUP_N_1V8 0.08493f
C25 a_11972_18220# a_11972_18060# 0.15007f
C26 LELO_GR03_1.x7.PWRUP_N_1V8 a_22462_6128# 0.08565f
C27 LELO_GR03_1.BIAS_CIRCUIT2_0.xb7.D a_11962_11042# 0.23115f
C28 LELO_GR03_1.x1.x21.x6.S a_8392_9667# 0.03733f
C29 LELO_GR03_1.BIAS_CIRCUIT2_0.xb7.D VDPWR 1.05643f
C30 LELO_GR03_1.x7.PWRUP_1V8 a_5192_9667# 0.0258f
C31 LELO_GR03_1.x1.x21.x6.G a_7592_13683# 0.01304f
C32 LELO_GR03_1.x1.x21.x3<1>.D a_6292_11283# 0.05639f
C33 a_13042_5544# a_13474_5544# 0.14233f
C34 LELO_GR03_1.x1.x9.D VDPWR 0.50766f
C35 LELO_GR03_1.x7.x10.D a_23662_4068# 0.01812f
C36 LELO_GR03_1.x12<1>.A a_16136_15088# 0.01207f
C37 LELO_GR03_1.x10.XA7.MP1.S LELO_GR03_1.x10.XA7.MN0.S 0.05173f
C38 LELO_GR03_1.x10.XA7.C a_26988_5288# 0.06949f
C39 LELO_GR03_1.x10.XA7.CN a_26148_5288# 0.06325f
C40 LELO_GR03_1.x7.VB_N a_14828_3076# 0.01382f
C41 uio_out<0> uo_out<7> 0.03102f
C42 a_8932_18060# LELO_GR03_1.x1.x18.S 0.0657f
C43 LELO_GR03_1.x1.x14.D a_8932_15560# 0.01174f
C44 LELO_GR03_1.x1.x21.x6.S a_6792_9507# 0.0371f
C45 LELO_GR03_1.x7.PWRUP_N_1V8 a_20862_5968# 0.01423f
C46 a_14214_13128# VDPWR 0.67267f
C47 LELO_GR03_1.x7.PWRUP_N_1V8 a_13690_11042# 0.03508f
C48 LELO_GR03_1.x1.x21.x6.G LELO_GR03_1.x1.x21.x4.G 2.0254f
C49 LELO_GR03_1.x1.x21.x3<1>.D a_7592_12083# 0.12415f
C50 a_8932_15560# VDPWR 0.47171f
C51 LELO_GR03_1.x7.x8.S a_18262_2128# 0.03993f
C52 LELO_GR03_1.x7.x10.D a_21862_2968# 0.01803f
C53 LELO_GR03_1.x1.x21.OUT LELO_GR03_1.x1.x21.x3<1>.D 0.1454f
C54 LELO_GR03_1.x1.x18.G a_12732_15060# 0.03397f
C55 a_13690_11042# a_14122_11042# 0.21349f
C56 LELO_GR03_1.x10.XA7.C a_26148_5288# 0.01225f
C57 a_10620_5354# VDPWR 0.11589f
C58 a_8932_18060# LELO_GR03_1.x7.PWRUP_N_1V8 0.08311f
C59 LELO_GR03_1.x1.VB_P a_12826_11042# 0.01378f
C60 LELO_GR03_1.x1.x21.x6.S a_6792_9667# 0.0369f
C61 LELO_GR03_1.x7.PWRUP_N_1V8 a_20862_6128# 0.09959f
C62 LELO_GR03_1.x7.x6.G LELO_GR03_1.x7.VB_N 0.89742f
C63 a_14214_13288# VDPWR 0.70074f
C64 a_22462_6128# a_22462_5968# 0.15007f
C65 LELO_GR03_1.x7.INN a_14554_11042# 0.03268f
C66 LELO_GR03_1.x7.PWRUP_N_1V8 a_13474_9122# 0.03751f
C67 LELO_GR03_1.x1.x21.INP LELO_GR03_1.x1.XQ2.Emitter 0.25278f
C68 LELO_GR03_1.x1.x21.x3<1>.S a_8892_11283# 0.05639f
C69 LELO_GR03_1.x1.x21.x6.G a_3932_8957# 0.02128f
C70 LELO_GR03_1.x1.x21.x3<1>.D a_8892_12883# 0.03722f
C71 a_10072_16360# VDPWR 0.49601f
C72 LELO_GR03_1.x10.XA7.C LELO_GR03_1.x10.XA1.MN1.S 0.07714f
C73 LELO_GR03_1.x10.XA6.A a_26988_4008# 0.06499f
C74 LELO_GR03_1.x1.x18.G LELO_GR03_1.x1.x15.G 0.37563f
C75 a_11212_15560# a_11472_15060# 0.01109f
C76 LELO_GR03_1.x10.CK LELO_GR03_1.BIAS_CIRCUIT2_0.xb6.S 0.55068f
C77 LELO_GR03_1.x10.XA7.CN LELO_GR03_1.x10.XA7.MP1.S 0.07161f
C78 LELO_GR03_1.x7.VB_N a_13420_3076# 0.01238f
C79 uio_out<1> uio_out<0> 0.03102f
C80 LELO_GR03_1.BIAS_CIRCUIT2_0.xb7.D a_11530_9122# 0.01216f
C81 LELO_GR03_1.x1.x21.x6.S a_5192_9507# 0.04074f
C82 a_4992_9867# a_5192_9667# 0.01928f
C83 LELO_GR03_1.x12<1>.A a_14338_5544# 0.01289f
C84 LELO_GR03_1.x7.PWRUP_N_1V8 a_19262_5968# 0.01397f
C85 a_12614_13128# VDPWR 0.67748f
C86 a_26988_3528# a_26988_3208# 0.01f
C87 LELO_GR03_1.x7.INN a_14338_9122# 0.01679f
C88 a_3500_8957# a_3932_8957# 0.01515f
C89 LELO_GR03_1.x1.x21.x3<1>.D LELO_GR03_1.x1.VB_P 1.14014f
C90 a_11212_17200# VDPWR 0.54627f
C91 a_12610_2046# VDPWR 0.01059f
C92 LELO_GR03_1.x7.x8.S a_16662_2128# 0.0398f
C93 a_16662_2968# a_16662_2768# 0.07221f
C94 LELO_GR03_1.x10.XA7.C a_26988_3208# 0.1046f
C95 LELO_GR03_1.x10.XA6.A a_26148_4008# 0.05912f
C96 LELO_GR03_1.x1.x21.INP a_7592_12083# 0.07099f
C97 a_13474_9122# a_13906_9122# 0.14233f
C98 LELO_GR03_1.x12<1>.A LELO_GR03_1.x7.x7<2>.S 3.68148f
C99 LELO_GR03_1.x10.CK a_14732_4108# 0.01313f
C100 LELO_GR03_1.x10.XA7.C LELO_GR03_1.x10.XA7.MP1.S 0.04215f
C101 LELO_GR03_1.x7.VB_N LELO_GR03_1.x7.x8.S 2.04366f
C102 a_10188_5354# VDPWR 0.06222f
C103 LELO_GR03_1.x1.x14.D LELO_GR03_1.x1.x11.D 0.06816f
C104 LELO_GR03_1.x1.x21.INP LELO_GR03_1.x1.x21.OUT 1.13542f
C105 a_8092_15234# LELO_GR03_1.x7.PWRUP_N_1V8 0.03139f
C106 a_10452_18220# a_10452_18060# 0.15007f
C107 LELO_GR03_1.x1.x21.x6.S a_5192_9667# 0.02924f
C108 LELO_GR03_1.x7.PWRUP_N_1V8 a_19262_6128# 0.10081f
C109 a_12614_13288# VDPWR 0.69991f
C110 LELO_GR03_1.x1.x21.x3<1>.S a_8892_12083# 0.12399f
C111 LELO_GR03_1.x1.x11.D VDPWR 0.44846f
C112 LELO_GR03_1.x7.x8.S a_21462_2768# 0.0611f
C113 LELO_GR03_1.x10.XA7.C a_26148_3208# 0.09819f
C114 LELO_GR03_1.x10.XA7.CN a_26988_3528# 0.04767f
C115 a_21862_3768# LELO_GR03_1.x7.x10.D 0.01549f
C116 LELO_GR03_1.x10.XA6.A LELO_GR03_1.x10.XA4.MP1.S 0.01889f
C117 a_16976_15408# LELO_GR03_1.x7.PWRUP_1V8 0.01772f
C118 LELO_GR03_1.x12<1>.A a_16662_4568# 0.07882f
C119 a_16662_4968# a_16662_4568# 0.03739f
C120 LELO_GR03_1.x10.XA7.C LELO_GR03_1.x10.XA7.CN 0.47409f
C121 uio_out<2> uio_out<1> 0.03102f
C122 LELO_GR03_1.x7.INN LELO_GR03_1.x1.x18.S 1.48837f
C123 LELO_GR03_1.x1.x14.D a_8932_16360# 0.02722f
C124 LELO_GR03_1.x1.x21.x6.S a_8892_9867# 0.07792f
C125 LELO_GR03_1.BIAS_CIRCUIT2_0.xc4.D VDPWR 2.64839f
C126 a_26148_3528# a_26148_3208# 0.01f
C127 LELO_GR03_1.x7.PWRUP_N_1V8 a_13258_11042# 0.07921f
C128 LELO_GR03_1.x1.x21.x3<1>.D a_6292_12083# 0.12503f
C129 a_8932_16360# VDPWR 0.49443f
C130 LELO_GR03_1.x7.x8.S a_19862_2608# 0.05627f
C131 LELO_GR03_1.x10.XA7.C a_26988_3528# 0.06653f
C132 LELO_GR03_1.x10.XA7.CN a_26148_3528# 0.04737f
C133 LELO_GR03_1.x7.VB_N VDPWR 0.20303f
C134 a_16136_15408# LELO_GR03_1.x7.PWRUP_1V8 0.01871f
C135 LELO_GR03_1.x1.x21.INP LELO_GR03_1.x1.VB_P 0.12712f
C136 LELO_GR03_1.x12<1>.A a_14732_4270# 0.01465f
C137 LELO_GR03_1.x7.x20.G LELO_GR03_1.x7.x7<2>.S 2.23394f
C138 a_9972_5354# VDPWR 0.03746f
C139 LELO_GR03_1.x7.INN LELO_GR03_1.x7.PWRUP_N_1V8 1.60304f
C140 LELO_GR03_1.x1.VB_P a_12394_11042# 0.01378f
C141 LELO_GR03_1.x1.x21.x6.S a_7592_9867# 0.0815f
C142 LELO_GR03_1.x7.PWRUP_N_1V8 a_22462_6608# 0.08085f
C143 a_11314_13288# VDPWR 0.55272f
C144 a_20862_6128# a_20862_5968# 0.15007f
C145 LELO_GR03_1.x7.INN a_14122_11042# 0.01392f
C146 LELO_GR03_1.x7.PWRUP_N_1V8 a_13042_9122# 0.04195f
C147 LELO_GR03_1.x7.PWRUP_1V8 a_4992_9867# 0.02145f
C148 a_12732_14260# a_12614_13288# 0.01214f
C149 LELO_GR03_1.x1.x21.x3<1>.D a_7592_12883# 0.1265f
C150 a_10072_17200# VDPWR 0.51909f
C151 a_12826_7464# a_13258_7464# 0.21349f
C152 LELO_GR03_1.x7.x8.S a_19862_2768# 0.06297f
C153 LELO_GR03_1.x10.XA7.CN LELO_GR03_1.x10.XA3.MP1.S 0.03112f
C154 LELO_GR03_1.x10.XA7.C a_26148_3528# 0.07292f
C155 LELO_GR03_1.x10.XA6.A a_26988_4488# 0.01281f
C156 LELO_GR03_1.x1.x18.S LELO_GR03_1.x1.x21.x11<1>.A 0.4743f
C157 LELO_GR03_1.x1.VB_P LELO_GR03_1.x7.x6.G 0.04106f
C158 LELO_GR03_1.x1.XQ2.Emitter VDPWR 0.04542f
C159 LELO_GR03_1.x7.VB_N a_14732_3308# 0.08186f
C160 LELO_GR03_1.x7.x20.G a_16662_4568# 0.01085f
C161 a_13430_4262# a_13424_4108# 0.12014f
C162 uio_out<3> uio_out<2> 0.03102f
C163 a_7660_15234# LELO_GR03_1.x7.PWRUP_N_1V8 0.01556f
C164 LELO_GR03_1.x1.x14.D LELO_GR03_1.x1.x17.D 1.31295f
C165 LELO_GR03_1.x1.x21.x6.S a_8892_10667# 0.05874f
C166 LELO_GR03_1.x12<1>.A a_13906_5544# 0.01127f
C167 a_6292_11283# VDPWR 0.54279f
C168 LELO_GR03_1.x7.PWRUP_1V8 LELO_GR03_1.x1.x21.x6.S 1.97521f
C169 LELO_GR03_1.x1.x21.x3<1>.D a_8892_13683# 0.02225f
C170 LELO_GR03_1.x1.x17.D VDPWR 0.44695f
C171 LELO_GR03_1.x7.x8.S a_18262_2608# 0.05026f
C172 LELO_GR03_1.x10.XA7.CN LELO_GR03_1.x10.XA3.MN1.S 0.0238f
C173 LELO_GR03_1.x7.PWRUP_N_1V8 LELO_GR03_1.x1.x21.x11<1>.A 0.04203f
C174 LELO_GR03_1.x1.x21.INP a_6292_12083# 0.08724f
C175 LELO_GR03_1.x7.VB_N a_13424_3308# 0.08906f
C176 a_8932_18220# a_8932_18060# 0.15007f
C177 LELO_GR03_1.x1.x14.D LELO_GR03_1.x1.x21.OUT 0.7124f
C178 LELO_GR03_1.x1.x21.x6.S a_6292_9867# 0.07729f
C179 LELO_GR03_1.x7.PWRUP_N_1V8 a_20862_6608# 0.0888f
C180 a_16662_5968# a_16662_5768# 0.08533f
C181 a_7592_12083# VDPWR 0.46598f
C182 a_3284_10877# LELO_GR03_1.x1.x21.x6.G 0.21991f
C183 LELO_GR03_1.x1.x21.OUT VDPWR 15.5738f
C184 a_12610_5544# a_13042_5544# 0.14233f
C185 LELO_GR03_1.x7.x8.S a_18262_2768# 0.05864f
C186 a_14828_2916# a_14828_2436# 0.02114f
C187 LELO_GR03_1.x10.XA7.C LELO_GR03_1.x10.XA3.MN1.S 0.01857f
C188 LELO_GR03_1.x10.XA7.CN a_26988_4008# 0.08626f
C189 LELO_GR03_1.x10.XA6.A LELO_GR03_1.x10.XA5.A 0.22909f
C190 a_16980_16158# a_16976_15408# 0.01328f
C191 LELO_GR03_1.x1.x21.INP a_7592_12883# 0.0705f
C192 LELO_GR03_1.x7.VB_N LELO_GR03_1.BIAS_CIRCUIT2_0.xb6.S 1.16238f
C193 LELO_GR03_1.x7.x20.G a_23662_4868# 0.09759f
C194 LELO_GR03_1.x10.CK a_14732_4270# 0.07712f
C195 uio_out<4> uio_out<3> 0.03102f
C196 a_7444_17154# LELO_GR03_1.x1.x18.S 0.04011f
C197 LELO_GR03_1.x1.x21.x6.S a_7592_10667# 0.05919f
C198 LELO_GR03_1.x7.PWRUP_N_1V8 a_20862_6768# 0.01486f
C199 a_8892_12883# VDPWR 0.46514f
C200 a_22462_6608# a_22462_6128# 0.02114f
C201 LELO_GR03_1.x7.PWRUP_N_1V8 a_12826_11042# 0.03624f
C202 LELO_GR03_1.x7.PWRUP_1V8 a_4992_10667# 0.01229f
C203 LELO_GR03_1.x1.x21.x3<1>.D a_6292_12883# 0.12629f
C204 a_8932_17200# VDPWR 0.47947f
C205 LELO_GR03_1.x7.x8.S a_16662_2608# 0.04949f
C206 LELO_GR03_1.x10.XA7.CN a_26148_4008# 0.02602f
C207 a_11962_3966# VDPWR 0.06561f
C208 LELO_GR03_1.x10.XA6.A a_26988_4808# 0.09795f
C209 LELO_GR03_1.x7.INN a_20562_2968# 0.06962f
C210 a_13258_11042# a_13690_11042# 0.21349f
C211 LELO_GR03_1.x7.VB_N a_14732_4108# 0.07116f
C212 uo_out<0> uio_in<7> 0.03102f
C213 LELO_GR03_1.x1.VB_P a_11962_11042# 0.01378f
C214 a_8892_11283# a_8892_10667# 0.02327f
C215 LELO_GR03_1.x7.PWRUP_N_1V8 a_19262_6608# 0.08961f
C216 LELO_GR03_1.x1.VB_P VDPWR 8.85786f
C217 a_19262_6128# a_19262_5968# 0.15007f
C218 LELO_GR03_1.x7.PWRUP_N_1V8 a_12610_9122# 0.01878f
C219 a_8392_13883# a_8892_13683# 0.01703f
C220 a_2852_8957# a_3932_8957# 0.0381f
C221 a_3068_8957# a_3500_8957# 0.14233f
C222 LELO_GR03_1.x1.x21.x3<1>.D a_7592_13683# 0.06844f
C223 a_11972_17420# VDPWR 0.79494f
C224 LELO_GR03_1.BIAS_CIRCUIT2_0.xa6.N a_15202_5544# 0.01216f
C225 LELO_GR03_1.x7.x8.S a_16662_2768# 0.05399f
C226 LELO_GR03_1.x10.XA7.CN LELO_GR03_1.x10.XA4.MP1.S 0.02318f
C227 LELO_GR03_1.x10.XA7.C a_26148_4008# 0.06561f
C228 LELO_GR03_1.x10.XA6.A a_26148_4808# 0.0777f
C229 LELO_GR03_1.x10.CK a_21462_1968# 0.03081f
C230 a_16140_16158# a_16136_15408# 0.01328f
C231 LELO_GR03_1.x1.x21.OUT a_12732_14260# 0.06998f
C232 LELO_GR03_1.x1.VB_P a_15202_5544# 0.1266f
C233 LELO_GR03_1.x7.INN a_21862_3768# 0.07338f
C234 LELO_GR03_1.x7.VB_N LELO_GR03_1.BIAS_CIRCUIT2_0.xc2.S 1.32706f
C235 uio_out<5> uio_out<4> 0.03102f
C236 uo_out<0> uo_out<1> 0.03102f
C237 a_7228_15234# LELO_GR03_1.x7.PWRUP_N_1V8 0.01101f
C238 LELO_GR03_1.x7.PWRUP_N_1V8 a_19262_6768# 0.02642f
C239 LELO_GR03_1.x7.x21.G a_16662_5768# 0.07119f
C240 a_4992_11283# VDPWR 0.69633f
C241 LELO_GR03_1.x1.x21.x11<1>.A LELO_GR03_1.x1.x21.x6.G 0.05672f
C242 LELO_GR03_1.x1.x21.x3<1>.D LELO_GR03_1.x1.x21.x4.G 2.34035f
C243 a_11472_14260# a_11314_13288# 0.01162f
C244 a_11972_17580# VDPWR 0.68142f
C245 LELO_GR03_1.x1.VB_P a_14732_3308# 0.01219f
C246 LELO_GR03_1.x10.XA7.CN LELO_GR03_1.x10.XA4.MN1.S 0.03049f
C247 LELO_GR03_1.x1.x21.INP a_6292_12883# 0.08721f
C248 a_13042_9122# a_13474_9122# 0.14233f
C249 LELO_GR03_1.x7.VB_N a_13424_4108# 0.08883f
C250 LELO_GR03_1.x1.x21.INP LELO_GR03_1.x1.x18.S 0.05862f
C251 a_6292_10667# LELO_GR03_1.x1.x21.x6.S 0.05699f
C252 LELO_GR03_1.x7.x21.S a_16662_5768# 0.09084f
C253 a_6292_12083# VDPWR 0.46637f
C254 LELO_GR03_1.x1.x15.G LELO_GR03_1.BIAS_CIRCUIT2_0.xc4.D 0.02348f
C255 a_6292_13683# LELO_GR03_1.x1.x21.x4.G 0.01414f
C256 a_10452_17420# VDPWR 0.78931f
C257 a_13420_2916# a_13420_2436# 0.02114f
C258 LELO_GR03_1.x10.XA7.CN a_26988_4488# 0.02605f
C259 a_11530_2046# VDPWR 0.01059f
C260 a_26988_5928# uo_out<0> 0.01873f
C261 LELO_GR03_1.x1.x21.INP a_7592_13683# 0.07881f
C262 LELO_GR03_1.x1.VB_P a_14770_5544# 0.0354f
C263 LELO_GR03_1.x7.INN a_20562_3768# 0.15326f
C264 LELO_GR03_1.x7.VB_N LELO_GR03_1.x7.x7<2>.S 1.08266f
C265 uio_out<6> uio_out<5> 0.03102f
C266 a_5288_15234# LELO_GR03_1.x1.x21.OUT 0.01083f
C267 LELO_GR03_1.x7.INN a_8092_15234# 0.06053f
C268 LELO_GR03_1.x1.x21.INP LELO_GR03_1.x7.PWRUP_N_1V8 0.17013f
C269 a_7592_11283# a_7592_10667# 0.02327f
C270 LELO_GR03_1.x7.PWRUP_N_1V8 a_17962_6768# 0.01373f
C271 a_20862_6608# a_20862_6128# 0.02114f
C272 a_7592_12883# VDPWR 0.46599f
C273 LELO_GR03_1.x7.PWRUP_N_1V8 a_12394_11042# 0.01542f
C274 LELO_GR03_1.x1.XQ2<3>.Emitter LELO_GR03_1.x1.XQ2.Emitter 1.30955f
C275 a_10452_17580# VDPWR 0.68189f
C276 LELO_GR03_1.x1.VB_P LELO_GR03_1.BIAS_CIRCUIT2_0.xb6.S 0.49304f
C277 LELO_GR03_1.x10.XA7.C a_26988_4488# 0.06678f
C278 LELO_GR03_1.x10.XA7.CN a_26148_4488# 0.08881f
C279 a_16662_5768# VDPWR 0.56515f
C280 LELO_GR03_1.x10.CK a_26988_2728# 0.06129f
C281 LELO_GR03_1.x1.x18.G LELO_GR03_1.x7.PWRUP_1V8 0.03561f
C282 a_8932_15560# a_8392_14683# 0.01053f
C283 a_16980_16478# a_16980_16158# 0.01f
C284 LELO_GR03_1.x1.x21.INP LELO_GR03_1.x1.x21.x4.G 1.23246f
C285 LELO_GR03_1.x1.XQ2<3>.Emitter a_6292_11283# 0.07414f
C286 LELO_GR03_1.x7.INN a_21862_4568# 0.07078f
C287 a_7660_15234# a_8092_15234# 0.01515f
C288 LELO_GR03_1.x7.PWRUP_N_1V8 LELO_GR03_1.x7.x6.G 0.01245f
C289 a_8892_13683# VDPWR 0.6499f
C290 LELO_GR03_1.x1.x21.x3<1>.D LELO_GR03_1.x1.x21.x6.G 1.87765f
C291 a_8932_17420# VDPWR 0.77437f
C292 LELO_GR03_1.x1.VB_P a_14732_4108# 0.02557f
C293 a_12394_7464# a_12826_7464# 0.21349f
C294 LELO_GR03_1.x10.XA7.CN LELO_GR03_1.x10.XA5.A 0.38708f
C295 a_26988_5928# VDPWR 0.31353f
C296 LELO_GR03_1.x10.D uo_out<0> 0.35767f
C297 LELO_GR03_1.x10.CK a_26148_2728# 0.06153f
C298 LELO_GR03_1.x12<1>.A LELO_GR03_1.x7.PWRUP_1V8 0.23938f
C299 a_10072_15560# a_10212_15060# 0.01081f
C300 LELO_GR03_1.x7.PWRUP_N_1V8 a_8392_14043# 0.08084f
C301 LELO_GR03_1.x1.x21.OUT a_12732_15060# 0.08881f
C302 LELO_GR03_1.x1.XQ2<3>.Emitter a_7592_12083# 0.07878f
C303 uio_out<7> uio_out<6> 0.03102f
C304 LELO_GR03_1.x1.XQ2<3>.Emitter LELO_GR03_1.x1.x21.OUT 0.13035f
C305 LELO_GR03_1.x7.PWRUP_N_1V8 LELO_GR03_1.x7.x21.G 1.0409f
C306 a_4992_12083# VDPWR 0.79059f
C307 LELO_GR03_1.x1.x21.x11<1>.A a_3284_10877# 0.23685f
C308 a_8932_17580# VDPWR 0.68081f
C309 LELO_GR03_1.x7.PWRUP_N_1V8 uo_out<0> 0.03288f
C310 LELO_GR03_1.BIAS_CIRCUIT2_0.xa6.N a_14554_7464# 0.22032f
C311 LELO_GR03_1.x10.XA7.C LELO_GR03_1.x10.XA5.A 0.08927f
C312 LELO_GR03_1.x10.XA7.CN a_26988_4808# 0.026f
C313 a_26988_6248# uo_out<0> 0.03476f
C314 a_16140_16478# a_16140_16158# 0.01f
C315 LELO_GR03_1.x1.x21.OUT LELO_GR03_1.x1.x15.G 1.22377f
C316 LELO_GR03_1.x1.VB_P a_14554_7464# 0.02143f
C317 LELO_GR03_1.x7.x21.S a_23662_3268# 0.12399f
C318 LELO_GR03_1.x7.x6.G a_21862_2968# 0.06957f
C319 LELO_GR03_1.x1.x14.D LELO_GR03_1.x1.x18.S 0.40691f
C320 a_5072_15234# LELO_GR03_1.x1.x21.OUT 0.01559f
C321 LELO_GR03_1.x7.PWRUP_N_1V8 LELO_GR03_1.x7.x21.S 1.62854f
C322 a_22462_6768# a_22462_6608# 0.15007f
C323 a_6292_12883# VDPWR 0.46652f
C324 LELO_GR03_1.x1.x18.S VDPWR 8.27691f
C325 LELO_GR03_1.x7.PWRUP_N_1V8 ui_in<0> 0.23988f
C326 a_12178_5544# a_12610_5544# 0.14233f
C327 LELO_GR03_1.x10.D VDPWR 2.18854f
C328 LELO_GR03_1.x10.XA7.CN a_26148_4808# 0.02661f
C329 a_26148_6248# uo_out<0> 0.02107f
C330 LELO_GR03_1.x1.x18.G a_12412_15580# 0.07466f
C331 LELO_GR03_1.x7.PWRUP_N_1V8 a_6792_14043# 0.08241f
C332 LELO_GR03_1.x1.x21.OUT a_10212_14260# 0.08303f
C333 LELO_GR03_1.x1.x21.INP LELO_GR03_1.x1.x21.x6.G 2.25153f
C334 LELO_GR03_1.x1.XQ2<3>.Emitter LELO_GR03_1.x1.VB_P 0.02327f
C335 LELO_GR03_1.x7.INN a_20562_4568# 0.07498f
C336 LELO_GR03_1.x7.x21.S a_23662_4068# 0.12405f
C337 LELO_GR03_1.x7.x6.G LELO_GR03_1.x7.x10.D 0.44419f
C338 uio_oe<0> uio_out<7> 0.03102f
C339 LELO_GR03_1.x1.x14.D LELO_GR03_1.x7.PWRUP_N_1V8 0.1696f
C340 a_19262_6608# a_19262_6128# 0.02114f
C341 a_7592_13683# VDPWR 0.65292f
C342 LELO_GR03_1.x10.XA5.A LELO_GR03_1.x10.XA3.MP1.S 0.04373f
C343 a_23662_3268# VDPWR 0.46404f
C344 a_2852_8957# a_3068_8957# 0.01515f
C345 LELO_GR03_1.x7.PWRUP_N_1V8 VDPWR 24.9448f
C346 LELO_GR03_1.BIAS_CIRCUIT2_0.xb6.S a_14828_2436# 0.03946f
C347 a_26988_6248# VDPWR 0.278f
C348 LELO_GR03_1.x7.x8.S a_21862_2968# 0.05812f
C349 LELO_GR03_1.x12<1>.A a_12412_15580# 0.01251f
C350 LELO_GR03_1.x1.x21.OUT a_11472_15060# 0.01208f
C351 LELO_GR03_1.x7.PWRUP_1V8 LELO_GR03_1.x10.CK 0.56191f
C352 a_12826_11042# a_13258_11042# 0.21349f
C353 a_5720_15234# LELO_GR03_1.x7.PWRUP_N_1V8 0.01426f
C354 LELO_GR03_1.x7.PWRUP_N_1V8 a_15202_5544# 0.01285f
C355 LELO_GR03_1.x7.PWRUP_1V8 LELO_GR03_1.BIAS_CIRCUIT2_0.xa5.N 0.2286f
C356 LELO_GR03_1.x7.x21.S a_22462_5968# 0.03732f
C357 LELO_GR03_1.x1.x21.x4.G VDPWR 1.59462f
C358 LELO_GR03_1.x10.XA5.A LELO_GR03_1.x10.XA3.MN1.S 0.04373f
C359 a_23662_4068# VDPWR 0.46402f
C360 LELO_GR03_1.x7.PWRUP_1V8 LELO_GR03_1.BIAS_CIRCUIT2_0.xb7.D 0.09712f
C361 a_11972_18060# VDPWR 0.68934f
C362 LELO_GR03_1.x7.x8.S LELO_GR03_1.x7.x10.D 1.64392f
C363 LELO_GR03_1.x7.PWRUP_N_1V8 a_5192_14043# 0.08251f
C364 LELO_GR03_1.x1.x21.OUT LELO_GR03_1.x1.x21.x3<1>.S 0.49228f
C365 LELO_GR03_1.x1.XQ2<3>.Emitter a_6292_12083# 0.07855f
C366 LELO_GR03_1.x10.CK LELO_GR03_1.x10.XA7.C 0.08598f
C367 LELO_GR03_1.x7.x20.G a_23162_4968# 0.08533f
C368 LELO_GR03_1.x7.x21.S LELO_GR03_1.x7.x10.D 1.67709f
C369 LELO_GR03_1.x7.x6.G a_21862_3768# 0.07064f
C370 uio_oe<1> uio_oe<0> 0.06577f
C371 a_7444_17154# LELO_GR03_1.x7.INN 0.23092f
C372 LELO_GR03_1.x7.PWRUP_1V8 a_11530_5544# 0.01292f
C373 LELO_GR03_1.x7.x21.S a_22462_6128# 0.04923f
C374 LELO_GR03_1.x10.XA5.A a_26988_4008# 0.02049f
C375 a_2852_8957# LELO_GR03_1.x1.x21.x11<1>.A 0.02026f
C376 LELO_GR03_1.x1.x21.x3<1>.S a_8892_12883# 0.12129f
C377 a_11972_18220# VDPWR 0.70434f
C378 LELO_GR03_1.x1.VB_P a_14732_4270# 0.01448f
C379 LELO_GR03_1.x7.PWRUP_1V8 a_19862_2128# 0.08081f
C380 a_22462_5968# VDPWR 0.77953f
C381 LELO_GR03_1.x7.x8.S a_20562_2968# 0.02172f
C382 LELO_GR03_1.x1.XQ2<3>.Emitter a_7592_12883# 0.07882f
C383 a_12610_9122# a_13042_9122# 0.14233f
C384 LELO_GR03_1.x7.x20.G a_21862_4968# 0.08054f
C385 a_5504_17154# LELO_GR03_1.x1.x18.S 0.04685f
C386 LELO_GR03_1.x7.PWRUP_N_1V8 a_14770_5544# 0.01329f
C387 LELO_GR03_1.x7.PWRUP_1V8 a_10620_5354# 0.13049f
C388 LELO_GR03_1.x7.x21.S a_20862_5968# 0.03573f
C389 a_20862_6768# a_20862_6608# 0.15007f
C390 LELO_GR03_1.x7.x10.D VDPWR 2.1742f
C391 LELO_GR03_1.x10.XA5.A a_26148_4008# 0.02736f
C392 LELO_GR03_1.x1.x21.x3<1>.S LELO_GR03_1.x1.VB_P 2.15099f
C393 a_10452_18060# VDPWR 0.68792f
C394 a_22462_6128# VDPWR 0.67804f
C395 LELO_GR03_1.x7.x8.S a_21862_3768# 0.05789f
C396 LELO_GR03_1.x7.PWRUP_N_1V8 a_16976_15088# 0.06129f
C397 LELO_GR03_1.x7.x20.G a_23162_5768# 0.08712f
C398 uio_oe<2> uio_oe<1> 0.06484f
C399 a_5288_15234# LELO_GR03_1.x1.x18.S 0.01153f
C400 a_7012_15234# a_8092_15234# 0.0381f
C401 a_7228_15234# a_7660_15234# 0.14233f
C402 LELO_GR03_1.x7.x21.S a_20862_6128# 0.05026f
C403 LELO_GR03_1.x7.x21.G a_19262_5968# 0.01189f
C404 LELO_GR03_1.x1.x21.x6.G VDPWR 3.15964f
C405 LELO_GR03_1.x10.XA5.A LELO_GR03_1.x10.XA4.MP1.S 0.05173f
C406 LELO_GR03_1.x7.PWRUP_1V8 a_18262_2128# 0.08478f
C407 a_10452_18220# VDPWR 0.7043f
C408 LELO_GR03_1.BIAS_CIRCUIT2_0.xc2.S a_13420_2436# 0.03934f
C409 a_20862_5968# VDPWR 0.77275f
C410 LELO_GR03_1.x7.x8.S a_19262_2968# 0.07043f
C411 LELO_GR03_1.x7.PWRUP_N_1V8 a_16136_15088# 0.0593f
C412 LELO_GR03_1.x7.PWRUP_1V8 a_12610_2046# 0.05866f
C413 LELO_GR03_1.x7.x20.G a_20562_4968# 0.08183f
C414 a_5288_15234# LELO_GR03_1.x7.PWRUP_N_1V8 0.01706f
C415 LELO_GR03_1.x1.x21.INP LELO_GR03_1.x7.INN 0.02905f
C416 LELO_GR03_1.x7.PWRUP_1V8 a_10188_5354# 0.01181f
C417 LELO_GR03_1.x7.x21.S a_19262_5968# 0.03494f
C418 LELO_GR03_1.x7.x21.G a_19262_6128# 0.01244f
C419 LELO_GR03_1.x10.XA5.A LELO_GR03_1.x10.XA4.MN1.S 0.07879f
C420 LELO_GR03_1.x7.PWRUP_1V8 a_12614_13288# 0.01505f
C421 a_8932_18060# VDPWR 0.67637f
C422 a_11962_7464# a_12394_7464# 0.21349f
C423 a_20862_6128# VDPWR 0.67916f
C424 LELO_GR03_1.x1.x18.G a_12412_16380# 0.17685f
C425 LELO_GR03_1.x12<1>.A a_11212_15560# 0.01447f
C426 LELO_GR03_1.x1.XQ2<3>.Emitter a_6292_12883# 0.07093f
C427 LELO_GR03_1.x7.x20.G a_21862_5768# 0.07846f
C428 LELO_GR03_1.x7.x21.G a_21862_4568# 0.02524f
C429 uio_oe<3> uio_oe<2> 0.06329f
C430 LELO_GR03_1.x1.XQ2<3>.Emitter LELO_GR03_1.x1.x18.S 0.1479f
C431 LELO_GR03_1.x7.PWRUP_N_1V8 a_14554_7464# 0.01792f
C432 LELO_GR03_1.x7.INN LELO_GR03_1.x7.x6.G 0.68776f
C433 LELO_GR03_1.x7.x21.S a_19262_6128# 0.05038f
C434 LELO_GR03_1.x7.x21.G a_17962_5968# 0.09361f
C435 LELO_GR03_1.x10.XA5.A a_26988_4488# 0.07964f
C436 LELO_GR03_1.x7.PWRUP_1V8 LELO_GR03_1.BIAS_CIRCUIT2_0.xc4.D 0.34625f
C437 LELO_GR03_1.x7.PWRUP_1V8 a_16662_2128# 0.08458f
C438 a_8932_18220# VDPWR 0.7034f
C439 a_19262_5968# VDPWR 0.74522f
C440 clk ena 0.03102f
C441 LELO_GR03_1.x7.PWRUP_1V8 LELO_GR03_1.x7.VB_N 1.26714f
C442 LELO_GR03_1.x7.x20.G a_19262_4968# 0.05037f
C443 a_5072_15234# LELO_GR03_1.x1.x18.S 0.06041f
C444 LELO_GR03_1.x1.x14.D a_8092_15234# 0.04003f
C445 LELO_GR03_1.x1.XQ2<3>.Emitter LELO_GR03_1.x7.PWRUP_N_1V8 0.09289f
C446 LELO_GR03_1.x7.PWRUP_N_1V8 a_14338_5544# 0.01763f
C447 LELO_GR03_1.x7.INN LELO_GR03_1.x7.x21.G 1.42571f
C448 a_14214_12648# a_14214_12488# 0.15007f
C449 LELO_GR03_1.x7.x21.S a_17962_5968# 0.06599f
C450 a_19262_6768# a_19262_6608# 0.15007f
C451 LELO_GR03_1.x10.XA5.A a_26148_4488# 0.09561f
C452 a_26988_4808# a_26988_4488# 0.01f
C453 LELO_GR03_1.x1.x21.OUT a_8892_9867# 0.01356f
C454 LELO_GR03_1.x1.x21.x3<1>.S a_8892_13683# 0.08661f
C455 LELO_GR03_1.x7.PWRUP_1V8 a_11314_13288# 0.01173f
C456 a_8092_15234# VDPWR 0.07857f
C457 a_11746_5544# a_12178_5544# 0.14233f
C458 a_19262_6128# VDPWR 0.67994f
C459 LELO_GR03_1.x7.x8.S a_17962_2968# 0.0715f
C460 LELO_GR03_1.x7.PWRUP_N_1V8 LELO_GR03_1.x1.x15.G 0.0958f
C461 LELO_GR03_1.x12<1>.A LELO_GR03_1.x1.x18.G 0.63422f
C462 LELO_GR03_1.x1.XQ2<3>.Emitter LELO_GR03_1.x1.x21.x4.G 2.79723f
C463 LELO_GR03_1.x7.INN LELO_GR03_1.x7.x8.S 0.04857f
C464 LELO_GR03_1.x7.PWRUP_1V8 a_12178_2046# 0.01053f
C465 LELO_GR03_1.x7.x20.G a_20562_5768# 0.07869f
C466 LELO_GR03_1.x7.x21.G a_19262_3768# 0.01303f
C467 uio_oe<4> uio_oe<3> 0.06143f
C468 LELO_GR03_1.x7.INN LELO_GR03_1.x7.x21.S 0.41262f
C469 LELO_GR03_1.x7.PWRUP_1V8 LELO_GR03_1.x1.XQ2.Emitter 0.04176f
C470 LELO_GR03_1.x7.x21.S a_22462_6608# 0.03976f
C471 a_21862_4568# VDPWR 0.01947f
C472 a_6292_13683# LELO_GR03_1.x1.x21.x3<1>.D 0.0599f
C473 LELO_GR03_1.x7.PWRUP_1V8 a_19862_2608# 0.08464f
C474 a_17962_5968# VDPWR 0.57973f
C475 LELO_GR03_1.x7.x8.S a_19262_3768# 0.05703f
C476 rst_n clk 0.03102f
C477 LELO_GR03_1.x1.x21.OUT a_10212_15060# 0.13092f
C478 a_12394_11042# a_12826_11042# 0.21349f
C479 LELO_GR03_1.x7.x20.G a_17962_4968# 0.05421f
C480 LELO_GR03_1.x7.x21.G a_20562_4568# 0.01135f
C481 LELO_GR03_1.x7.x6.G a_16662_2968# 0.08813f
C482 LELO_GR03_1.x1.x14.D LELO_GR03_1.x7.INN 0.56168f
C483 LELO_GR03_1.x1.x21.INP a_7444_17154# 0.22067f
C484 LELO_GR03_1.x7.x21.S a_22462_6768# 0.01139f
C485 a_26988_4808# LELO_GR03_1.x10.XA5.A 0.05912f
C486 a_26148_4808# a_26148_4488# 0.01f
C487 LELO_GR03_1.x1.x21.OUT a_8892_10667# 0.04084f
C488 LELO_GR03_1.x7.INN VDPWR 2.34055f
C489 a_22462_6608# VDPWR 0.67349f
C490 LELO_GR03_1.x1.x9.D a_11212_15560# 0.03869f
C491 LELO_GR03_1.x1.x21.OUT LELO_GR03_1.x7.PWRUP_1V8 0.80337f
C492 LELO_GR03_1.x1.x21.INP LELO_GR03_1.x1.x21.x3<1>.D 3.06003f
C493 LELO_GR03_1.x7.x20.G a_19262_5768# 0.01654f
C494 uio_oe<5> uio_oe<4> 0.06143f
C495 LELO_GR03_1.x1.x21.INP a_7228_15234# 0.01483f
C496 LELO_GR03_1.x7.PWRUP_N_1V8 a_14122_7464# 0.025f
C497 LELO_GR03_1.x7.x21.S a_20862_6608# 0.03993f
C498 a_26148_4808# LELO_GR03_1.x10.XA5.A 0.06582f
C499 LELO_GR03_1.x1.x21.x3<1>.S a_7592_13683# 0.01987f
C500 LELO_GR03_1.x7.PWRUP_1V8 a_18262_2608# 0.09996f
C501 a_22462_6768# VDPWR 0.686f
C502 LELO_GR03_1.x7.x8.S a_16662_2968# 0.0683f
C503 a_14828_3076# a_14828_2916# 0.15007f
C504 a_12412_17180# LELO_GR03_1.x1.x18.G 0.08567f
C505 a_11212_16360# LELO_GR03_1.x12<1>.A 0.01907f
C506 LELO_GR03_1.x7.PWRUP_N_1V8 LELO_GR03_1.x1.x21.x3<1>.S 1.40819f
C507 LELO_GR03_1.x1.x21.INP a_6292_13683# 0.02387f
C508 LELO_GR03_1.x1.XQ2<3>.Emitter LELO_GR03_1.x1.x21.x6.G 0.53872f
C509 a_12178_9122# a_12610_9122# 0.14233f
C510 LELO_GR03_1.x12<1>.A LELO_GR03_1.x7.x20.G 0.06724f
C511 LELO_GR03_1.x7.x20.G a_16662_4968# 0.03163f
C512 LELO_GR03_1.x7.x21.G a_17962_3768# 0.01303f
C513 LELO_GR03_1.x10.D LELO_GR03_1.x10.XA6.MP1.S 0.04519f
C514 a_7012_15234# a_7228_15234# 0.01515f
C515 LELO_GR03_1.x7.PWRUP_N_1V8 a_13906_5544# 0.02938f
C516 a_12614_12648# a_12614_12488# 0.15007f
C517 LELO_GR03_1.x7.x21.S a_20862_6768# 0.01151f
C518 LELO_GR03_1.x7.x21.G a_19262_6608# 0.02033f
C519 LELO_GR03_1.x1.x21.x4.G li_6290_10467# 0.38947f
C520 LELO_GR03_1.x1.x21.x11<1>.A VDPWR 0.46498f
C521 a_20562_4568# VDPWR 0.01895f
C522 LELO_GR03_1.x7.PWRUP_1V8 LELO_GR03_1.x1.VB_P 0.47339f
C523 LELO_GR03_1.x7.PWRUP_1V8 a_18262_2768# 0.01733f
C524 LELO_GR03_1.x7.x7<2>.S a_20562_2968# 0.04703f
C525 a_20862_6608# VDPWR 0.67472f
C526 LELO_GR03_1.x7.x8.S a_17962_3768# 0.05701f
C527 LELO_GR03_1.x1.x9.D LELO_GR03_1.x1.x18.G 0.06367f
C528 LELO_GR03_1.x7.PWRUP_N_1V8 a_8392_14523# 0.08587f
C529 LELO_GR03_1.x7.PWRUP_1V8 a_11746_2046# 0.01008f
C530 LELO_GR03_1.x1.x21.x6.S LELO_GR03_1.x1.XQ2.Emitter 0.02871f
C531 LELO_GR03_1.x12<1>.A LELO_GR03_1.x10.CK 0.48232f
C532 LELO_GR03_1.x7.x21.G a_19262_4568# 0.03749f
C533 LELO_GR03_1.x10.D LELO_GR03_1.x10.XA6.A 0.15699f
C534 LELO_GR03_1.x7.x20.G a_17962_5768# 0.01014f
C535 uio_oe<6> uio_oe<5> 0.06205f
C536 LELO_GR03_1.x7.x21.S a_19262_6608# 0.03996f
C537 LELO_GR03_1.x7.x21.G a_19262_6768# 0.01061f
C538 LELO_GR03_1.x7.x6.G a_16662_5968# 0.01962f
C539 LELO_GR03_1.x7.PWRUP_1V8 a_4992_11283# 0.01164f
C540 LELO_GR03_1.x7.PWRUP_1V8 a_16662_2608# 0.09981f
C541 LELO_GR03_1.BIAS_CIRCUIT2_0.xa5.N a_11962_7464# 0.22774f
C542 LELO_GR03_1.x7.x7<2>.S a_21862_3768# 0.05639f
C543 a_20862_6768# VDPWR 0.688f
C544 ui_in<2> ui_in<1> 0.03102f
C545 LELO_GR03_1.x1.x9.D LELO_GR03_1.x12<1>.A 0.67642f
C546 LELO_GR03_1.x1.x21.OUT a_12412_15580# 0.04002f
C547 LELO_GR03_1.x12<1>.A a_13430_4262# 0.01325f
C548 LELO_GR03_1.x10.D LELO_GR03_1.x10.XA6.MN1.S 0.05644f
C549 LELO_GR03_1.x1.x14.D a_7444_17154# 0.02457f
C550 a_7012_15234# LELO_GR03_1.x1.x21.INP 0.10664f
C551 LELO_GR03_1.BIAS_CIRCUIT2_0.xb7.D a_12614_12488# 0.05828f
C552 a_14214_13128# a_14214_12648# 0.02114f
C553 a_6292_11283# a_6292_10667# 0.02327f
C554 a_4992_12883# VDPWR 0.77937f
C555 LELO_GR03_1.x7.x21.S a_19262_6768# 0.01152f
C556 LELO_GR03_1.x7.x21.G a_16662_5968# 0.07068f
C557 LELO_GR03_1.x1.x21.OUT LELO_GR03_1.x1.x21.x6.S 0.55327f
C558 a_6792_13883# a_6292_13683# 0.03405f
C559 LELO_GR03_1.x7.PWRUP_1V8 a_16662_2768# 0.01934f
C560 LELO_GR03_1.BIAS_CIRCUIT2_0.xa5.N a_11746_5544# 0.04489f
C561 LELO_GR03_1.x7.x7<2>.S a_19262_2968# 0.01236f
C562 a_19262_6608# VDPWR 0.67476f
C563 LELO_GR03_1.x7.PWRUP_N_1V8 a_6792_14523# 0.09935f
C564 LELO_GR03_1.x7.PWRUP_1V8 a_11530_2046# 0.06396f
C565 LELO_GR03_1.x12<1>.A a_14732_5070# 0.076f
C566 LELO_GR03_1.x10.D a_26988_5288# 0.02349f
C567 uio_oe<7> uio_oe<6> 0.06422f
C568 a_6152_15234# LELO_GR03_1.x1.x21.INP 0.03853f
C569 LELO_GR03_1.x7.PWRUP_N_1V8 a_13690_7464# 0.04398f
C570 LELO_GR03_1.x1.x21.x4.G a_6792_9667# 0.01056f
C571 LELO_GR03_1.BIAS_CIRCUIT2_0.xb7.D a_12614_12648# 0.04375f
C572 LELO_GR03_1.x1.x21.x3<1>.D VDPWR 2.41308f
C573 LELO_GR03_1.x7.x21.S a_16662_5968# 0.06401f
C574 LELO_GR03_1.x7.x21.G a_17962_6768# 0.09813f
C575 LELO_GR03_1.x7.x10.D a_21462_1968# 0.06994f
C576 a_19262_4568# VDPWR 0.01895f
C577 LELO_GR03_1.x1.x21.x3<1>.S LELO_GR03_1.x1.x21.x6.G 0.01873f
C578 a_8392_14043# a_8392_13883# 0.15007f
C579 a_11530_5544# a_11746_5544# 0.01515f
C580 LELO_GR03_1.x7.x7<2>.S a_20562_3768# 0.12141f
C581 LELO_GR03_1.x10.CK a_23662_2468# 0.05381f
C582 a_19262_6768# VDPWR 0.68795f
C583 a_13420_3076# a_13420_2916# 0.15007f
C584 ui_in<3> ui_in<2> 0.03102f
C585 LELO_GR03_1.x1.x9.D a_11212_16360# 0.10742f
C586 LELO_GR03_1.x12<1>.A a_13430_5062# 0.04354f
C587 LELO_GR03_1.x10.D a_26148_5288# 0.03117f
C588 a_6152_15234# a_7012_15234# 0.04873f
C589 LELO_GR03_1.x7.INN a_14554_7464# 0.02181f
C590 LELO_GR03_1.x7.PWRUP_N_1V8 a_13474_5544# 0.06303f
C591 LELO_GR03_1.BIAS_CIRCUIT2_0.xb7.D a_11314_12488# 0.01854f
C592 a_6292_13683# VDPWR 0.62842f
C593 LELO_GR03_1.x7.x21.S a_17962_6768# 0.05715f
C594 LELO_GR03_1.x7.x21.G LELO_GR03_1.x7.x6.G 1.01765f
C595 LELO_GR03_1.x7.PWRUP_1V8 a_14828_2436# 0.0886f
C596 LELO_GR03_1.x7.x7<2>.S a_21862_4568# 0.06098f
C597 LELO_GR03_1.x10.CK a_19862_1968# 0.01836f
C598 a_16662_5968# VDPWR 0.58001f
C599 LELO_GR03_1.x7.PWRUP_N_1V8 a_5192_14523# 0.08991f
C600 LELO_GR03_1.x7.INN a_12732_15060# 0.01006f
C601 LELO_GR03_1.x7.x6.G LELO_GR03_1.x7.x8.S 2.76219f
C602 a_26988_5928# LELO_GR03_1.x10.XA7.CN 0.06207f
C603 LELO_GR03_1.x10.D LELO_GR03_1.x10.XA7.MN0.S 0.01917f
C604 LELO_GR03_1.x1.x14.D LELO_GR03_1.x1.x21.INP 0.27258f
C605 LELO_GR03_1.BIAS_CIRCUIT2_0.xc4.D a_14214_12488# 0.01026f
C606 a_4992_13683# VDPWR 0.73617f
C607 LELO_GR03_1.x7.x21.S LELO_GR03_1.x7.x6.G 1.20345f
C608 LELO_GR03_1.x1.x21.OUT a_8892_11283# 0.03616f
C609 a_5192_13883# a_4992_13683# 0.06482f
C610 LELO_GR03_1.x1.x21.INP VDPWR 7.05993f
C611 a_11530_5544# LELO_GR03_1.BIAS_CIRCUIT2_0.xa5.N 0.18782f
C612 LELO_GR03_1.x7.x21.G uo_out<0> 0.0853f
C613 LELO_GR03_1.x7.x7<2>.S a_17962_2968# 0.01112f
C614 a_17962_6768# VDPWR 0.54126f
C615 ui_in<4> ui_in<3> 0.03102f
C616 LELO_GR03_1.x7.INN LELO_GR03_1.x1.x15.G 0.0916f
C617 a_11962_11042# a_12394_11042# 0.21349f
C618 LELO_GR03_1.x7.INN LELO_GR03_1.x7.x7<2>.S 2.82705f
C619 LELO_GR03_1.x7.x6.G a_16662_3768# 0.09829f
C620 a_14732_5070# LELO_GR03_1.x10.CK 0.07196f
C621 LELO_GR03_1.x10.D LELO_GR03_1.x10.XA7.MP1.S 0.34151f
C622 a_5720_15234# LELO_GR03_1.x1.x21.INP 0.0678f
C623 LELO_GR03_1.x1.x14.D a_7012_15234# 0.0457f
C624 LELO_GR03_1.BIAS_CIRCUIT2_0.xc4.D a_14214_12648# 0.0401f
C625 a_12614_13128# a_12614_12648# 0.02114f
C626 a_8392_13883# VDPWR 0.78987f
C627 LELO_GR03_1.x7.x21.S LELO_GR03_1.x7.x21.G 8.14807f
C628 a_16662_6768# LELO_GR03_1.x7.x6.G 0.01359f
C629 a_19862_2128# a_19862_1968# 0.15007f
C630 LELO_GR03_1.x12<1>.A LELO_GR03_1.BIAS_CIRCUIT2_0.xc4.D 0.01457f
C631 LELO_GR03_1.x7.PWRUP_1V8 a_13420_2436# 0.08533f
C632 a_14732_3308# a_14828_3076# 0.02043f
C633 LELO_GR03_1.x7.x7<2>.S a_19262_3768# 0.10027f
C634 LELO_GR03_1.x10.CK a_18262_1968# 0.01852f
C635 LELO_GR03_1.x7.x6.G VDPWR 1.22992f
C636 LELO_GR03_1.x1.x11.D a_10072_15560# 0.03793f
C637 LELO_GR03_1.x1.x21.OUT a_11212_15560# 0.08603f
C638 LELO_GR03_1.x12<1>.A LELO_GR03_1.x7.VB_N 0.12226f
C639 LELO_GR03_1.x10.D LELO_GR03_1.x10.XA7.CN 0.37141f
C640 a_26148_5928# LELO_GR03_1.x10.XA7.C 0.06698f
C641 LELO_GR03_1.x7.x21.G a_16662_3768# 0.01303f
C642 ui_in<0> uo_out<0> 0.02867f
C643 LELO_GR03_1.x1.x14.D a_6152_15234# 0.08396f
C644 LELO_GR03_1.x7.PWRUP_N_1V8 a_13258_7464# 0.08418f
C645 LELO_GR03_1.x1.x21.x4.G a_7592_9867# 0.07044f
C646 LELO_GR03_1.x1.VB_P a_8892_11283# 0.07221f
C647 a_4992_11283# a_4992_10667# 0.02327f
C648 a_8392_14043# VDPWR 0.68147f
C649 a_16662_6768# LELO_GR03_1.x7.x21.G 0.09397f
C650 LELO_GR03_1.x1.x21.OUT a_8892_12083# 0.01336f
C651 a_6792_14043# a_6792_13883# 0.15007f
C652 a_10620_5354# a_11530_5544# 0.0422f
C653 LELO_GR03_1.BIAS_CIRCUIT2_0.xb6.S a_14828_2916# 0.04723f
C654 a_16662_3768# LELO_GR03_1.x7.x8.S 0.05692f
C655 LELO_GR03_1.x7.x7<2>.S a_20562_4568# 0.07802f
C656 LELO_GR03_1.x10.D a_26988_3528# 0.0631f
C657 LELO_GR03_1.x7.x21.G VDPWR 12.6987f
C658 ui_in<5> ui_in<4> 0.03102f
C659 LELO_GR03_1.x1.x21.OUT a_12412_16380# 0.01326f
C660 LELO_GR03_1.x7.PWRUP_N_1V8 LELO_GR03_1.x7.PWRUP_1V8 0.61233f
C661 LELO_GR03_1.x7.INN a_11472_15060# 0.01272f
C662 a_11746_9122# a_12178_9122# 0.14233f
C663 LELO_GR03_1.x10.D LELO_GR03_1.x10.XA7.C 0.87755f
C664 LELO_GR03_1.x7.x21.G a_17962_4568# 0.03987f
C665 VDPWR uo_out<0> 1.84972f
C666 a_5720_15234# a_6152_15234# 0.01515f
C667 LELO_GR03_1.x7.PWRUP_N_1V8 a_13042_5544# 0.06487f
C668 a_14214_13288# a_14214_13128# 0.15007f
C669 a_12614_13128# LELO_GR03_1.BIAS_CIRCUIT2_0.xb7.D 0.0391f
C670 a_6792_13883# VDPWR 0.79062f
C671 a_16662_6768# LELO_GR03_1.x7.x21.S 0.05705f
C672 LELO_GR03_1.x7.PWRUP_1V8 LELO_GR03_1.x1.x21.x4.G 0.16458f
C673 LELO_GR03_1.BIAS_CIRCUIT2_0.xb6.S a_14828_3076# 0.03584f
C674 LELO_GR03_1.x10.CK a_16662_1968# 0.02019f
C675 LELO_GR03_1.x10.D a_26148_3528# 0.05912f
C676 LELO_GR03_1.x7.x21.S VDPWR 12.243f
C677 a_11212_17200# LELO_GR03_1.x1.x9.D 0.01206f
C678 LELO_GR03_1.x1.x21.OUT LELO_GR03_1.x1.x18.G 1.18369f
C679 LELO_GR03_1.x7.PWRUP_N_1V8 a_16976_15408# 0.05952f
C680 VDPWR ui_in<0> 0.90759f
C681 LELO_GR03_1.x12<1>.A a_15202_9122# 0.03379f
C682 LELO_GR03_1.x1.x21.x6.G a_8892_9867# 0.07046f
C683 LELO_GR03_1.x1.x21.x4.G a_6292_9867# 0.08332f
C684 LELO_GR03_1.BIAS_CIRCUIT2_0.xc4.D a_11314_12488# 0.05642f
C685 a_12614_13288# LELO_GR03_1.BIAS_CIRCUIT2_0.xb7.D 0.01008f
C686 LELO_GR03_1.x1.VB_P a_8892_12083# 0.15627f
C687 a_6792_14043# VDPWR 0.68353f
C688 LELO_GR03_1.x1.x14.D VDPWR 0.60681f
C689 a_13424_3308# a_13420_3076# 0.05991f
C690 LELO_GR03_1.x7.x7<2>.S a_17962_3768# 0.07541f
C691 LELO_GR03_1.x10.D LELO_GR03_1.x10.XA3.MP1.S 0.0112f
C692 a_16662_6768# VDPWR 0.53893f
C693 ui_in<6> ui_in<5> 0.03102f
C694 LELO_GR03_1.x1.x21.OUT LELO_GR03_1.x12<1>.A 0.68406f
C695 LELO_GR03_1.x1.x18.S a_12412_15580# 0.0564f
C696 LELO_GR03_1.x7.PWRUP_N_1V8 a_16136_15408# 0.08793f
C697 LELO_GR03_1.x1.XQ2<3>.Emitter LELO_GR03_1.x1.x21.x3<1>.D 3.50912f
C698 LELO_GR03_1.x7.VB_N LELO_GR03_1.x10.CK 0.41201f
C699 LELO_GR03_1.BIAS_CIRCUIT2_0.xc4.D LELO_GR03_1.BIAS_CIRCUIT2_0.xb7.D 0.03585f
C700 LELO_GR03_1.x1.x21.x6.G a_7592_9867# 0.01323f
C701 LELO_GR03_1.x1.x21.x4.G a_7592_10667# 0.07186f
C702 LELO_GR03_1.x1.VB_P a_14214_12488# 0.04522f
C703 a_5192_13883# VDPWR 0.77762f
C704 a_17962_4568# VDPWR 0.01895f
C705 a_18262_2128# a_18262_1968# 0.15007f
C706 a_10188_5354# a_10620_5354# 0.01515f
C707 LELO_GR03_1.x7.x7<2>.S a_19262_4568# 0.05947f
C708 LELO_GR03_1.x10.CK a_21462_2768# 0.01432f
C709 a_15202_5544# VDPWR 0.01511f
C710 LELO_GR03_1.x1.x21.OUT a_10072_15560# 0.10521f
C711 LELO_GR03_1.x1.XQ2<3>.Emitter a_6292_13683# 0.0727f
C712 LELO_GR03_1.x7.PWRUP_N_1V8 a_12826_7464# 0.03624f
C713 LELO_GR03_1.x12<1>.A LELO_GR03_1.BIAS_CIRCUIT2_0.xa6.N 0.06571f
C714 LELO_GR03_1.x1.x21.x6.G a_8892_10667# 0.07107f
C715 LELO_GR03_1.x1.VB_P a_14214_12648# 0.01043f
C716 LELO_GR03_1.BIAS_CIRCUIT2_0.xc4.D a_14214_13128# 0.04889f
C717 a_5192_14043# VDPWR 0.68401f
C718 LELO_GR03_1.x12<1>.A LELO_GR03_1.x1.VB_P 1.50666f
C719 LELO_GR03_1.x7.PWRUP_1V8 LELO_GR03_1.x1.x21.x6.G 0.13568f
C720 a_5192_14043# a_5192_13883# 0.15007f
C721 LELO_GR03_1.BIAS_CIRCUIT2_0.xc2.S a_13420_2916# 0.04665f
C722 ui_in<7> ui_in<6> 0.03102f
C723 LELO_GR03_1.x1.x11.D a_10072_16360# 0.10585f
C724 LELO_GR03_1.x1.x21.OUT a_11212_16360# 0.1613f
C725 LELO_GR03_1.x1.XQ2<3>.Emitter LELO_GR03_1.x1.x21.INP 2.19394f
C726 LELO_GR03_1.x7.PWRUP_N_1V8 a_12610_5544# 0.02331f
C727 LELO_GR03_1.x1.x21.x4.G LELO_GR03_1.x1.x21.x6.S 2.63692f
C728 LELO_GR03_1.x1.VB_P a_12614_12488# 0.03595f
C729 LELO_GR03_1.BIAS_CIRCUIT2_0.xc4.D a_14214_13288# 0.02895f
C730 a_12614_13288# a_12614_13128# 0.15007f
C731 a_9972_5354# a_10620_5354# 0.06667f
C732 LELO_GR03_1.BIAS_CIRCUIT2_0.xc2.S a_13420_3076# 0.0341f
C733 LELO_GR03_1.x7.PWRUP_N_1V8 a_16140_16158# 0.01541f
C734 a_11530_9122# VDPWR 0.01362f
C735 a_5504_17154# LELO_GR03_1.x1.x14.D 0.23245f
C736 LELO_GR03_1.x1.x21.x6.G a_7592_10667# 0.03679f
C737 LELO_GR03_1.x1.x21.x4.G a_6292_10667# 0.10773f
C738 LELO_GR03_1.x1.VB_P a_12614_12648# 0.01036f
C739 a_16976_15088# VDPWR 0.28375f
C740 a_14770_5544# a_15202_5544# 0.01515f
C741 a_19862_2608# a_19862_2128# 0.02114f
C742 LELO_GR03_1.BIAS_CIRCUIT2_0.xb6.S VDPWR 0.0145f
C743 LELO_GR03_1.x1.x21.x3<1>.S LELO_GR03_1.x1.x21.x3<1>.D 1.3458f
C744 uio_in<0> ui_in<7> 0.03102f
C745 LELO_GR03_1.x1.x17.D a_8932_15560# 0.03794f
C746 LELO_GR03_1.x1.x21.OUT LELO_GR03_1.x1.x9.D 0.91741f
C747 LELO_GR03_1.x7.PWRUP_N_1V8 a_16980_16478# 0.02121f
C748 a_11530_9122# a_11746_9122# 0.01515f
C749 LELO_GR03_1.x7.VB_N a_12610_2046# 0.05602f
C750 LELO_GR03_1.x7.x6.G LELO_GR03_1.x7.x7<2>.S 1.09604f
C751 LELO_GR03_1.x1.XQ2<3>.Emitter a_6152_15234# 0.0196f
C752 LELO_GR03_1.BIAS_CIRCUIT2_0.xc4.D a_12614_13288# 0.01172f
C753 LELO_GR03_1.x1.VB_P a_11314_12488# 0.10812f
C754 LELO_GR03_1.BIAS_CIRCUIT2_0.xa5.N a_11962_3966# 0.2189f
C755 a_16662_2128# a_16662_1968# 0.15007f
C756 LELO_GR03_1.x1.VB_P LELO_GR03_1.x10.CK 0.4856f
C757 a_9972_5354# a_10188_5354# 0.01515f
C758 LELO_GR03_1.BIAS_CIRCUIT2_0.xb6.S a_14732_3308# 0.09041f
C759 a_11972_17420# a_12412_17180# 0.016f
C760 LELO_GR03_1.x1.x21.OUT a_8932_15560# 0.09368f
C761 LELO_GR03_1.x7.PWRUP_N_1V8 a_16140_16478# 0.05285f
C762 a_12178_2046# a_12610_2046# 0.01515f
C763 LELO_GR03_1.x7.x21.G LELO_GR03_1.x7.x7<2>.S 2.9858f
C764 a_5072_15234# a_6152_15234# 0.0381f
C765 a_5288_15234# a_5720_15234# 0.14233f
C766 LELO_GR03_1.x7.PWRUP_N_1V8 a_12394_7464# 0.01542f
C767 LELO_GR03_1.x1.x21.x6.G LELO_GR03_1.x1.x21.x6.S 1.66371f
C768 LELO_GR03_1.x1.VB_P LELO_GR03_1.BIAS_CIRCUIT2_0.xb7.D 0.87271f
C769 LELO_GR03_1.BIAS_CIRCUIT2_0.xc2.S VDPWR 0.01994f
C770 LELO_GR03_1.x7.x7<2>.S LELO_GR03_1.x7.x8.S 2.03566f
C771 uio_in<1> uio_in<0> 0.03102f
C772 LELO_GR03_1.x1.x21.INP LELO_GR03_1.x1.x21.x3<1>.S 0.8365f
C773 a_10072_17200# LELO_GR03_1.x1.x11.D 0.01251f
C774 LELO_GR03_1.x1.x21.OUT a_10072_16360# 0.16501f
C775 LELO_GR03_1.x1.x18.S a_12412_16380# 0.1229f
C776 a_22462_5968# a_21862_5768# 0.02379f
C777 LELO_GR03_1.x7.x21.S LELO_GR03_1.x7.x7<2>.S 0.03734f
C778 LELO_GR03_1.x7.x21.G a_16662_4568# 0.03188f
C779 LELO_GR03_1.x1.XQ2<3>.Emitter LELO_GR03_1.x1.x14.D 0.03828f
C780 a_11314_13288# LELO_GR03_1.BIAS_CIRCUIT2_0.xc4.D 0.0738f
C781 a_12732_15060# VDPWR 0.02927f
C782 LELO_GR03_1.x1.x21.x3<1>.S a_8392_13883# 0.02064f
C783 LELO_GR03_1.x1.VB_P a_14732_5070# 0.01332f
C784 LELO_GR03_1.x1.XQ2<3>.Emitter VDPWR 6.09807f
C785 LELO_GR03_1.x7.x7<2>.S a_16662_3768# 0.05778f
C786 LELO_GR03_1.x7.INN LELO_GR03_1.x7.PWRUP_1V8 0.16785f
C787 LELO_GR03_1.x1.x21.OUT a_11212_17200# 0.07044f
C788 LELO_GR03_1.x1.x18.S LELO_GR03_1.x1.x18.G 1.86988f
C789 LELO_GR03_1.x1.XQ2<3>.Emitter a_5720_15234# 0.06019f
C790 LELO_GR03_1.BIAS_CIRCUIT2_0.xa5.N a_11530_2046# 0.01585f
C791 LELO_GR03_1.x7.x7<2>.S VDPWR 0.03776f
C792 a_18262_2608# a_18262_2128# 0.02114f
C793 LELO_GR03_1.x1.x21.x3<1>.S a_8392_14043# 0.05754f
C794 LELO_GR03_1.x1.XQ2.Emitter a_9972_5354# 0.03326f
C795 LELO_GR03_1.BIAS_CIRCUIT2_0.xc2.S a_13424_3308# 0.08956f
C796 a_14732_4108# LELO_GR03_1.BIAS_CIRCUIT2_0.xb6.S 0.05699f
C797 LELO_GR03_1.x7.x7<2>.S a_17962_4568# 0.06095f
C798 LELO_GR03_1.x10.D LELO_GR03_1.x10.XA5.A 0.0469f
C799 uio_in<2> uio_in<1> 0.03102f
C800 LELO_GR03_1.x1.x18.S LELO_GR03_1.x12<1>.A 0.3023f
C801 LELO_GR03_1.x1.x17.D a_8932_16360# 0.10684f
C802 LELO_GR03_1.x1.x21.OUT LELO_GR03_1.x1.x11.D 1.02978f
C803 LELO_GR03_1.x7.PWRUP_N_1V8 LELO_GR03_1.x1.x18.G 0.59568f
C804 LELO_GR03_1.x7.x21.G a_23662_4868# 0.0111f
C805 a_16662_4568# VDPWR 0.02214f
C806 LELO_GR03_1.x7.PWRUP_1V8 LELO_GR03_1.x1.x21.x11<1>.A 0.02822f
C807 LELO_GR03_1.x7.PWRUP_N_1V8 a_14214_12648# 0.08188f
C808 a_8392_14523# a_8392_14043# 0.02114f
C809 LELO_GR03_1.x1.x21.x3<1>.S a_6792_13883# 0.01719f
C810 a_28996_20830# VDPWR 0.35852f
C811 LELO_GR03_1.BIAS_CIRCUIT2_0.xc2.S LELO_GR03_1.BIAS_CIRCUIT2_0.xb6.S 0.02024f
C812 a_21862_4968# a_21862_4568# 0.03739f
C813 LELO_GR03_1.x1.x21.OUT a_8932_16360# 0.16503f
C814 LELO_GR03_1.x7.PWRUP_N_1V8 LELO_GR03_1.x12<1>.A 1.60483f
C815 a_8392_9027# a_8392_8867# 0.15007f
C816 LELO_GR03_1.x7.x21.S a_23662_4868# 0.06238f
C817 LELO_GR03_1.x1.x21.x6.G a_7592_11283# 0.04821f
C818 a_11472_15060# VDPWR 0.03208f
C819 a_14338_5544# a_14770_5544# 0.14233f
C820 LELO_GR03_1.x7.x8.S a_21462_1968# 0.04993f
C821 LELO_GR03_1.x1.x15.G a_12732_14260# 0.06802f
C822 LELO_GR03_1.x1.x21.x3<1>.S a_6792_14043# 0.05599f
C823 uio_in<3> uio_in<2> 0.03102f
C824 LELO_GR03_1.x1.x21.OUT a_10072_17200# 0.0702f
C825 LELO_GR03_1.x1.x18.S a_11212_16360# 0.06101f
C826 LELO_GR03_1.x7.INN a_12412_15580# 0.01567f
C827 a_20862_5968# a_20562_5768# 0.05456f
C828 a_11962_3966# LELO_GR03_1.x7.VB_N 0.22285f
C829 LELO_GR03_1.x1.XQ2<3>.Emitter a_5504_17154# 0.22929f
C830 LELO_GR03_1.x1.VB_P LELO_GR03_1.BIAS_CIRCUIT2_0.xc4.D 1.56435f
C831 LELO_GR03_1.x1.x21.x3<1>.S VDPWR 5.15225f
C832 a_23662_4868# VDPWR 0.61536f
C833 a_19862_2768# a_19862_2608# 0.15007f
C834 LELO_GR03_1.x10.XA6.A uo_out<0> 0.0107f
C835 LELO_GR03_1.x7.PWRUP_N_1V8 a_12614_12648# 0.09191f
C836 a_28996_21150# VDPWR 0.39823f
C837 LELO_GR03_1.x1.VB_P LELO_GR03_1.x7.VB_N 0.38386f
C838 LELO_GR03_1.x7.VB_N a_18262_2768# 0.01445f
C839 LELO_GR03_1.x7.x20.G a_23662_3268# 0.07055f
C840 LELO_GR03_1.x1.x21.OUT LELO_GR03_1.x1.x17.D 1.03026f
C841 LELO_GR03_1.x1.x18.S a_12412_17180# 0.09066f
C842 LELO_GR03_1.x7.PWRUP_N_1V8 LELO_GR03_1.x7.x20.G 0.67265f
C843 a_11530_2046# a_12610_2046# 0.0381f
C844 LELO_GR03_1.x1.XQ2<3>.Emitter a_5288_15234# 0.0418f
C845 LELO_GR03_1.x1.VB_P a_11314_13288# 0.08771f
C846 a_8392_14523# VDPWR 0.68567f
C847 a_16662_2608# a_16662_2128# 0.02114f
C848 LELO_GR03_1.x10.XA6.MP1.S VDPWR 0.08534f
C849 LELO_GR03_1.x1.x21.x3<1>.S a_5192_14043# 0.04394f
C850 JNWTR_TIEL_CV_0.Y uo_out<0> 0.0716f
C851 a_13424_4108# LELO_GR03_1.BIAS_CIRCUIT2_0.xc2.S 0.05705f
C852 LELO_GR03_1.x10.CK a_23662_3268# 0.01442f
C853 LELO_GR03_1.x7.x20.G a_23662_4068# 0.17318f
C854 uio_in<4> uio_in<3> 0.03102f
C855 LELO_GR03_1.x1.x18.S LELO_GR03_1.x1.x9.D 0.81883f
C856 a_8932_17200# LELO_GR03_1.x1.x17.D 0.01179f
C857 LELO_GR03_1.x7.PWRUP_N_1V8 a_12412_17180# 0.01429f
C858 LELO_GR03_1.x7.PWRUP_N_1V8 LELO_GR03_1.x10.CK 0.02422f
C859 a_11746_2046# a_12178_2046# 0.14233f
C860 a_26988_2408# VDPWR 0.3676f
C861 a_5072_15234# a_5288_15234# 0.01515f
C862 a_8392_14683# VDPWR 0.70605f
C863 LELO_GR03_1.x10.XA6.A VDPWR 1.35257f
C864 LELO_GR03_1.x1.XQ2<3>.Emitter a_6792_8867# 0.01215f
C865 LELO_GR03_1.x7.PWRUP_N_1V8 LELO_GR03_1.BIAS_CIRCUIT2_0.xb7.D 0.60508f
C866 a_6792_14523# a_6792_14043# 0.02114f
C867 LELO_GR03_1.x1.x15.G a_11472_14260# 0.09786f
C868 LELO_GR03_1.BIAS_CIRCUIT2_0.xa6.N a_15202_9122# 0.15179f
C869 JNWTR_TIEL_CV_0.Y ui_in<0> 0.12763f
C870 JNWTR_TIEL_CV_0.MP0.G VDPWR 0.57072f
C871 LELO_GR03_1.x7.PWRUP_1V8 a_14828_2916# 0.08426f
C872 LELO_GR03_1.x7.PWRUP_N_1V8 LELO_GR03_1.x1.x9.D 0.0318f
C873 a_8932_17200# LELO_GR03_1.x1.x21.OUT 0.07043f
C874 LELO_GR03_1.x7.PWRUP_N_1V8 a_13430_4262# 0.07077f
C875 LELO_GR03_1.x1.VB_P a_15202_9122# 0.12779f
C876 a_6792_9027# a_6792_8867# 0.15007f
C877 a_22462_5968# LELO_GR03_1.x7.x20.G 0.01636f
C878 a_26148_2408# VDPWR 0.01514f
C879 a_6792_14523# VDPWR 0.68691f
C880 LELO_GR03_1.x7.PWRUP_N_1V8 a_14214_13128# 0.08638f
C881 LELO_GR03_1.x1.x15.G a_12732_15060# 0.04988f
C882 LELO_GR03_1.x7.PWRUP_1V8 a_4992_13683# 0.01109f
C883 LELO_GR03_1.x1.x21.OUT LELO_GR03_1.x1.VB_P 0.55103f
C884 a_14770_9122# a_15202_9122# 0.01515f
C885 JNWTR_TIEL_CV_0.Y VDPWR 0.02653f
C886 LELO_GR03_1.x7.x20.G LELO_GR03_1.x7.x10.D 1.17387f
C887 a_20562_4968# a_20562_4568# 0.03739f
C888 a_14732_4270# a_14732_4108# 0.11281f
C889 uio_in<5> uio_in<4> 0.03102f
C890 LELO_GR03_1.x1.x21.INP LELO_GR03_1.x7.PWRUP_1V8 0.80654f
C891 a_10452_17420# a_10072_17200# 0.02945f
C892 LELO_GR03_1.x1.x18.S a_10072_16360# 0.06064f
C893 a_19262_5968# a_19262_5768# 0.08533f
C894 a_26988_2728# VDPWR 0.40216f
C895 a_5072_15234# LELO_GR03_1.x1.XQ2<3>.Emitter 0.10899f
C896 LELO_GR03_1.x1.VB_P a_8892_12883# 0.14793f
C897 a_6792_14683# VDPWR 0.69106f
C898 a_18262_2768# a_18262_2608# 0.15007f
C899 a_26988_5288# VDPWR 0.36276f
C900 LELO_GR03_1.x7.x10.D a_23662_2468# 0.07289f
C901 LELO_GR03_1.x1.x21.OUT a_4992_11283# 0.01163f
C902 LELO_GR03_1.x7.PWRUP_1V8 a_13420_2916# 0.10205f
C903 a_28996_21470# VDPWR 0.2855f
C904 LELO_GR03_1.x10.CK LELO_GR03_1.x7.x10.D 1.54399f
C905 LELO_GR03_1.x7.x20.G a_20562_2968# 0.0111f
C906 LELO_GR03_1.x1.x18.S a_11212_17200# 0.08198f
C907 LELO_GR03_1.x7.INN a_11212_15560# 0.01734f
C908 LELO_GR03_1.x7.PWRUP_N_1V8 a_13430_5062# 0.07672f
C909 LELO_GR03_1.x7.PWRUP_1V8 LELO_GR03_1.x7.x6.G 0.06131f
C910 LELO_GR03_1.x1.VB_P LELO_GR03_1.BIAS_CIRCUIT2_0.xa6.N 0.88038f
C911 a_8392_9507# a_8392_9027# 0.02114f
C912 a_20862_5968# LELO_GR03_1.x7.x20.G 0.01108f
C913 LELO_GR03_1.x1.x21.x3<1>.D LELO_GR03_1.x1.x21.x6.S 0.01133f
C914 a_5192_14523# VDPWR 0.68603f
C915 a_14122_7464# a_14554_7464# 0.21349f
C916 a_26148_5288# VDPWR 0.06902f
C917 LELO_GR03_1.x10.XA7.MP1.S uo_out<0> 0.08268f
C918 LELO_GR03_1.x7.PWRUP_N_1V8 a_12614_13128# 0.10676f
C919 LELO_GR03_1.x7.PWRUP_1V8 a_13420_3076# 0.01515f
C920 a_14770_9122# LELO_GR03_1.BIAS_CIRCUIT2_0.xa6.N 0.08791f
C921 a_16662_4568# LELO_GR03_1.x7.x7<2>.S 0.06126f
C922 LELO_GR03_1.x7.x20.G a_21862_3768# 0.02527f
C923 uio_in<6> uio_in<5> 0.03102f
C924 LELO_GR03_1.x1.x18.S LELO_GR03_1.x1.x11.D 0.79454f
C925 LELO_GR03_1.x1.VB_P a_14770_9122# 0.0354f
C926 LELO_GR03_1.x10.XA1.MN1.S VDPWR 0.01198f
C927 a_5192_14683# VDPWR 0.68988f
C928 LELO_GR03_1.x10.XA7.CN uo_out<0> 0.25437f
C929 LELO_GR03_1.x10.XA7.MN0.S VDPWR 0.01218f
C930 LELO_GR03_1.x7.PWRUP_N_1V8 a_12614_13288# 0.03106f
C931 a_5192_14523# a_5192_14043# 0.02114f
C932 a_11472_15060# LELO_GR03_1.x1.x15.G 0.11207f
C933 LELO_GR03_1.x7.PWRUP_1V8 LELO_GR03_1.x7.x8.S 1.64754f
C934 LELO_GR03_1.x1.XQ2<3>.Emitter LELO_GR03_1.x1.x21.x3<1>.S 0.04091f
C935 a_11972_17580# a_11972_17420# 0.15007f
C936 LELO_GR03_1.x1.x18.S a_8932_16360# 0.06046f
C937 LELO_GR03_1.x7.INN LELO_GR03_1.x1.x18.G 0.31804f
C938 a_5192_9027# a_5192_8867# 0.15007f
C939 a_26988_3208# VDPWR 0.38807f
C940 LELO_GR03_1.x7.PWRUP_1V8 ui_in<0> 0.02431f
C941 a_10212_15060# VDPWR 0.03012f
C942 a_13906_5544# a_14338_5544# 0.14233f
C943 LELO_GR03_1.x10.XA7.C uo_out<0> 0.15831f
C944 LELO_GR03_1.x10.XA7.MP1.S VDPWR 0.32956f
C945 LELO_GR03_1.x1.x21.INP LELO_GR03_1.x1.x21.x6.S 0.0457f
C946 LELO_GR03_1.x7.PWRUP_N_1V8 LELO_GR03_1.BIAS_CIRCUIT2_0.xc4.D 1.28669f
C947 LELO_GR03_1.x7.x20.G a_20562_3768# 0.03426f
C948 uio_in<7> uio_in<6> 0.03102f
C949 LELO_GR03_1.x7.INN LELO_GR03_1.x12<1>.A 2.77172f
C950 LELO_GR03_1.x1.x18.S a_10072_17200# 0.07485f
C951 LELO_GR03_1.x7.PWRUP_N_1V8 LELO_GR03_1.x7.VB_N 0.05558f
C952 a_11530_2046# a_11746_2046# 0.01515f
C953 a_8892_10667# VDPWR 0.01265f
C954 a_17962_5968# a_17962_5768# 0.08533f
C955 LELO_GR03_1.x7.x21.G a_23162_4968# 0.0133f
C956 a_26148_3208# VDPWR 0.07316f
C957 LELO_GR03_1.x7.PWRUP_1V8 VDPWR 5.03316f
C958 a_16662_2768# a_16662_2608# 0.15007f
C959 LELO_GR03_1.x10.XA7.CN VDPWR 1.62967f
C960 LELO_GR03_1.x12<1>.A a_19262_3768# 0.07101f
C961 a_14554_11042# LELO_GR03_1.BIAS_CIRCUIT2_0.xa6.N 0.23425f
C962 LELO_GR03_1.x7.x20.G a_21862_4568# 0.0395f
C963 a_19262_4968# a_19262_4568# 0.03739f
C964 LELO_GR03_1.x1.x18.S LELO_GR03_1.x1.x17.D 0.80848f
C965 a_8932_17420# a_8932_17200# 0.064f
C966 LELO_GR03_1.x7.INN a_10072_15560# 0.01682f
C967 LELO_GR03_1.x1.VB_P a_14554_11042# 0.0352f
C968 a_6792_9507# a_6792_9027# 0.02114f
C969 LELO_GR03_1.x7.x21.S a_23162_4968# 0.06753f
C970 LELO_GR03_1.x7.x21.G a_21862_4968# 0.05013f
C971 a_26988_3528# VDPWR 0.31332f
C972 a_28996_21150# a_28996_20830# 0.01f
C973 LELO_GR03_1.x1.x21.x3<1>.D a_7592_11283# 0.05639f
C974 a_8892_13683# LELO_GR03_1.x1.VB_P 0.07058f
C975 a_16976_15408# VDPWR 0.27933f
C976 LELO_GR03_1.x10.XA7.C VDPWR 3.20291f
C977 LELO_GR03_1.x7.PWRUP_N_1V8 LELO_GR03_1.x1.x17.D 0.0606f
C978 LELO_GR03_1.x1.x18.S LELO_GR03_1.x1.x21.OUT 12.2299f
C979 LELO_GR03_1.x7.INN LELO_GR03_1.x7.x20.G 2.3874f
C980 a_7592_10667# VDPWR 0.01148f
C981 LELO_GR03_1.x7.x21.S a_21862_4968# 0.04684f
C982 LELO_GR03_1.x7.x21.G a_23162_5768# 0.01538f
C983 LELO_GR03_1.x1.x21.x3<1>.D a_8892_12083# 0.01317f
C984 LELO_GR03_1.x1.x21.x4.G a_6292_11283# 0.0416f
C985 a_23162_4968# VDPWR 0.59077f
C986 a_21862_2968# a_21462_2768# 0.04431f
C987 a_14338_9122# a_14770_9122# 0.14233f
C988 a_10452_17580# a_10452_17420# 0.15007f
C989 LELO_GR03_1.x1.x18.S a_8932_17200# 0.07244f
C990 LELO_GR03_1.x7.PWRUP_N_1V8 LELO_GR03_1.x1.x21.OUT 0.29926f
C991 a_8392_9667# a_8392_9507# 0.15007f
C992 LELO_GR03_1.x7.x21.S a_23162_5768# 0.08385f
C993 LELO_GR03_1.x7.x21.G a_20562_4968# 0.03493f
C994 LELO_GR03_1.x10.XA3.MP1.S VDPWR 0.09448f
C995 a_28156_21150# a_28156_20830# 0.01f
C996 LELO_GR03_1.x7.PWRUP_1V8 a_11530_9122# 0.01991f
C997 LELO_GR03_1.x1.x21.x4.G a_7592_12083# 0.01351f
C998 a_12412_15580# VDPWR 0.54241f
C999 a_16980_16158# ui_in<0> 0.07602f
C1000 a_21862_4968# VDPWR 0.52496f
C1001 LELO_GR03_1.x7.x10.D a_21462_2768# 0.09553f
C1002 LELO_GR03_1.x1.x21.OUT LELO_GR03_1.x1.x21.x4.G 0.34092f
C1003 a_8392_14523# LELO_GR03_1.x1.x21.x3<1>.S 0.04101f
C1004 LELO_GR03_1.x1.x21.INP a_7592_11283# 0.08607f
C1005 LELO_GR03_1.x7.PWRUP_1V8 LELO_GR03_1.BIAS_CIRCUIT2_0.xb6.S 0.45409f
C1006 LELO_GR03_1.x12<1>.A a_17962_3768# 0.08363f
C1007 LELO_GR03_1.x7.x20.G a_20562_4568# 0.01397f
C1008 uo_out<2> uo_out<1> 0.03102f
C1009 LELO_GR03_1.x7.INN LELO_GR03_1.x1.x9.D 0.23662f
C1010 LELO_GR03_1.x1.x18.S a_11972_17420# 0.02372f
C1011 LELO_GR03_1.x1.x21.x6.S VDPWR 0.03785f
C1012 LELO_GR03_1.x7.x21.S a_20562_4968# 0.04684f
C1013 LELO_GR03_1.x7.x21.G a_21862_5768# 0.01025f
C1014 a_16980_16158# VDPWR 0.29671f
C1015 a_16140_16158# ui_in<0> 0.08303f
C1016 a_23162_5768# VDPWR 0.63147f
C1017 a_14828_2436# a_14828_2276# 0.15007f
C1018 a_16976_15408# a_16976_15088# 0.01f
C1019 LELO_GR03_1.x7.PWRUP_1V8 a_16136_15088# 0.0195f
C1020 LELO_GR03_1.x7.PWRUP_N_1V8 LELO_GR03_1.x1.VB_P 0.80564f
C1021 LELO_GR03_1.x12<1>.A a_19262_4568# 0.07046f
C1022 a_5288_15234# LELO_GR03_1.x7.PWRUP_1V8 0.02257f
C1023 LELO_GR03_1.x1.x18.S a_11972_17580# 0.04794f
C1024 LELO_GR03_1.x7.PWRUP_N_1V8 a_11972_17420# 0.01151f
C1025 LELO_GR03_1.x1.VB_P a_14122_11042# 0.02096f
C1026 a_5192_9507# a_5192_9027# 0.02114f
C1027 a_6292_10667# VDPWR 0.01148f
C1028 LELO_GR03_1.x7.x21.S a_21862_5768# 0.09483f
C1029 LELO_GR03_1.x7.x21.G a_19262_4968# 0.08036f
C1030 a_26988_4008# VDPWR 0.31476f
C1031 JNWTR_TIEL_CV_0.MP0.G a_28996_21150# 0.06636f
C1032 LELO_GR03_1.x1.x21.x4.G LELO_GR03_1.x1.VB_P 0.0492f
C1033 LELO_GR03_1.x7.PWRUP_1V8 a_8392_9027# 0.08555f
C1034 a_13690_7464# a_14122_7464# 0.21349f
C1035 a_16980_16478# ui_in<0> 0.05912f
C1036 a_20562_4968# VDPWR 0.52496f
C1037 LELO_GR03_1.x7.INN a_14214_13288# 0.01387f
C1038 a_6792_14523# LELO_GR03_1.x1.x21.x3<1>.S 0.04186f
C1039 a_8392_14683# a_8392_14523# 0.15007f
C1040 LELO_GR03_1.x7.PWRUP_1V8 LELO_GR03_1.BIAS_CIRCUIT2_0.xc2.S 0.5692f
C1041 LELO_GR03_1.x7.VB_N a_19262_2968# 0.07066f
C1042 uo_out<3> uo_out<2> 0.03102f
C1043 LELO_GR03_1.x7.PWRUP_N_1V8 a_11972_17580# 0.10074f
C1044 LELO_GR03_1.x1.x18.S a_10452_17420# 0.02328f
C1045 LELO_GR03_1.x7.INN a_10072_16360# 0.02772f
C1046 a_4992_10667# VDPWR 0.01148f
C1047 LELO_GR03_1.x7.x21.S a_19262_4968# 0.04682f
C1048 LELO_GR03_1.x7.x21.G a_20562_5768# 0.01137f
C1049 JNWTR_TIEL_CV_0.MP0.G a_28156_21150# 0.05912f
C1050 LELO_GR03_1.x1.x21.x6.G a_7592_12083# 0.02616f
C1051 a_16980_16478# VDPWR 0.29886f
C1052 a_16140_16478# ui_in<0> 0.06129f
C1053 a_21862_5768# VDPWR 0.63f
C1054 a_20562_2968# a_19862_2768# 0.03979f
C1055 LELO_GR03_1.x1.x21.OUT LELO_GR03_1.x1.x21.x6.G 1.32704f
C1056 a_16136_15408# a_16136_15088# 0.01f
C1057 LELO_GR03_1.x7.x20.G a_19262_4568# 0.02484f
C1058 LELO_GR03_1.x1.XQ2<3>.Emitter LELO_GR03_1.x7.PWRUP_1V8 0.41437f
C1059 a_11972_18060# a_11972_17580# 0.02114f
C1060 a_8932_17580# a_8932_17420# 0.15007f
C1061 LELO_GR03_1.x1.x18.S a_10452_17580# 0.05128f
C1062 LELO_GR03_1.BIAS_CIRCUIT2_0.xb7.D a_12826_11042# 0.01055f
C1063 a_6792_9667# a_6792_9507# 0.15007f
C1064 a_8892_11283# VDPWR 0.54178f
C1065 LELO_GR03_1.x7.x21.S a_20562_5768# 0.09483f
C1066 LELO_GR03_1.x7.x21.G a_17962_4968# 0.08488f
C1067 LELO_GR03_1.x10.XA4.MP1.S VDPWR 0.09506f
C1068 a_28996_21470# a_28996_21150# 0.01f
C1069 LELO_GR03_1.x7.PWRUP_1V8 a_6792_9027# 0.08775f
C1070 LELO_GR03_1.x1.x21.x4.G a_6292_12083# 0.01854f
C1071 a_13474_5544# a_13906_5544# 0.14233f
C1072 a_16140_16478# VDPWR 0.03156f
C1073 a_19262_4968# VDPWR 0.52496f
C1074 LELO_GR03_1.x7.PWRUP_1V8 LELO_GR03_1.x1.x15.G 0.19155f
C1075 a_5192_14523# LELO_GR03_1.x1.x21.x3<1>.S 0.03878f
C1076 uo_out<4> uo_out<3> 0.03102f
C1077 LELO_GR03_1.x7.INN LELO_GR03_1.x1.x11.D 1.39295f
C1078 LELO_GR03_1.x7.PWRUP_N_1V8 a_10452_17580# 0.09965f
C1079 LELO_GR03_1.x1.x18.S a_8932_17420# 0.02152f
C1080 LELO_GR03_1.x12<1>.A LELO_GR03_1.x7.x6.G 1.02054f
C1081 LELO_GR03_1.x1.x21.x6.S a_8392_8867# 0.01041f
C1082 a_7592_11283# VDPWR 0.54279f
C1083 LELO_GR03_1.x10.D a_26988_5928# 0.08349f
C1084 LELO_GR03_1.x7.x21.S a_17962_4968# 0.04686f
C1085 LELO_GR03_1.x7.x21.G a_19262_5768# 0.0725f
C1086 a_26988_2728# a_26988_2408# 0.01f
C1087 JNWTR_TIEL_CV_0.Y JNWTR_TIEL_CV_0.MP0.G 0.02571f
C1088 LELO_GR03_1.x1.x21.x4.G a_7592_12883# 0.01674f
C1089 LELO_GR03_1.x1.x21.x6.G LELO_GR03_1.x1.VB_P 0.38143f
C1090 a_11212_15560# VDPWR 0.468f
C1091 a_20562_5768# VDPWR 0.59897f
C1092 a_13420_2436# a_13420_2276# 0.15007f
C1093 LELO_GR03_1.x7.INN LELO_GR03_1.BIAS_CIRCUIT2_0.xc4.D 0.39054f
C1094 a_14122_11042# a_14554_11042# 0.21349f
C1095 LELO_GR03_1.x7.VB_N a_17962_2968# 0.08051f
C1096 LELO_GR03_1.x1.x18.S a_8932_17580# 0.05336f
C1097 LELO_GR03_1.x7.PWRUP_N_1V8 a_8932_17420# 0.01109f
C1098 LELO_GR03_1.x12<1>.A LELO_GR03_1.x7.x21.G 1.90663f
C1099 LELO_GR03_1.x7.INN LELO_GR03_1.x7.VB_N 0.02883f
C1100 LELO_GR03_1.x1.VB_P a_13690_11042# 0.01726f
C1101 LELO_GR03_1.x1.x21.x6.S a_8392_9027# 0.03827f
C1102 a_8892_9867# a_8392_9667# 0.06031f
C1103 a_8892_12083# VDPWR 0.47089f
C1104 LELO_GR03_1.x10.D a_26148_5928# 0.11744f
C1105 LELO_GR03_1.x7.x21.S a_19262_5768# 0.09483f
C1106 LELO_GR03_1.x7.x21.G a_16662_4968# 0.07913f
C1107 a_26988_6248# a_26988_5928# 0.01f
C1108 a_26988_4488# VDPWR 0.31025f
C1109 a_28156_21470# a_28156_21150# 0.01f
C1110 a_28996_21470# JNWTR_TIEL_CV_0.MP0.G 0.08348f
C1111 LELO_GR03_1.x7.PWRUP_1V8 a_5192_9027# 0.08706f
C1112 LELO_GR03_1.x1.x21.x6.G a_4992_11283# 0.02412f
C1113 LELO_GR03_1.x12<1>.A uo_out<0> 0.01489f
C1114 a_12412_16380# VDPWR 0.46525f
C1115 a_17962_4968# VDPWR 0.52496f
C1116 a_6792_14683# a_6792_14523# 0.15007f
C1117 LELO_GR03_1.x12<1>.A LELO_GR03_1.x7.x8.S 0.07137f
C1118 a_17962_4968# a_17962_4568# 0.03739f
C1119 LELO_GR03_1.x7.VB_N a_19262_3768# 0.07045f
C1120 uo_out<5> uo_out<4> 0.03102f
C1121 a_8092_15234# LELO_GR03_1.x1.x21.OUT 0.016f
C1122 LELO_GR03_1.x7.PWRUP_N_1V8 a_8932_17580# 0.09999f
C1123 LELO_GR03_1.x7.INN a_10072_17200# 0.01236f
C1124 LELO_GR03_1.x12<1>.A LELO_GR03_1.x7.x21.S 0.13622f
C1125 LELO_GR03_1.x1.x21.x6.S a_6792_8867# 0.01038f
C1126 a_14214_12488# VDPWR 0.51847f
C1127 LELO_GR03_1.x7.x6.G LELO_GR03_1.x7.x20.G 0.41094f
C1128 LELO_GR03_1.x7.x21.G a_17962_5768# 0.07806f
C1129 LELO_GR03_1.x7.x21.S a_16662_4968# 0.04677f
C1130 a_26148_2728# a_26148_2408# 0.01f
C1131 a_28156_21470# JNWTR_TIEL_CV_0.MP0.G 0.06129f
C1132 LELO_GR03_1.x7.PWRUP_1V8 a_8392_9507# 0.10021f
C1133 LELO_GR03_1.x1.x21.x6.G a_6292_12083# 0.01301f
C1134 LELO_GR03_1.x1.x18.G VDPWR 4.51863f
C1135 a_19262_5768# VDPWR 0.56481f
C1136 LELO_GR03_1.x1.x21.OUT a_3284_10877# 0.02485f
C1137 LELO_GR03_1.x1.XQ2<3>.Emitter LELO_GR03_1.x1.x21.x6.S 0.40338f
C1138 LELO_GR03_1.x12<1>.A a_16662_3768# 0.0837f
C1139 a_13906_9122# a_14338_9122# 0.14233f
C1140 ui_in<0> rst_n 0.03102f
C1141 LELO_GR03_1.x7.INN LELO_GR03_1.x1.x17.D 0.06511f
C1142 a_10452_18060# a_10452_17580# 0.02114f
C1143 LELO_GR03_1.x7.PWRUP_N_1V8 LELO_GR03_1.x1.x18.S 2.12117f
C1144 LELO_GR03_1.BIAS_CIRCUIT2_0.xb7.D a_12394_11042# 0.01147f
C1145 LELO_GR03_1.x1.x21.x6.S a_6792_9027# 0.03822f
C1146 a_5192_9667# a_5192_9507# 0.15007f
C1147 a_14214_12648# VDPWR 0.6559f
C1148 LELO_GR03_1.x7.x21.S a_17962_5768# 0.09483f
C1149 LELO_GR03_1.x7.x21.G LELO_GR03_1.x7.x20.G 8.06917f
C1150 LELO_GR03_1.x7.x6.G LELO_GR03_1.x10.CK 0.27008f
C1151 a_26988_6248# LELO_GR03_1.x10.D 0.07033f
C1152 a_26148_6248# a_26148_5928# 0.01f
C1153 LELO_GR03_1.x10.XA5.A VDPWR 0.75326f
C1154 a_28156_21470# JNWTR_TIEL_CV_0.Y 0.05539f
C1155 LELO_GR03_1.x7.INN a_15202_9122# 0.01671f
C1156 LELO_GR03_1.x7.PWRUP_1V8 a_8392_9667# 0.01767f
C1157 LELO_GR03_1.x1.x21.x4.G a_6292_12883# 0.0244f
C1158 LELO_GR03_1.x1.x21.x6.G a_7592_12883# 0.02117f
C1159 LELO_GR03_1.x12<1>.A VDPWR 2.74895f
C1160 a_16662_4968# VDPWR 0.52429f
C1161 LELO_GR03_1.x12<1>.A a_17962_4568# 0.07048f
C1162 LELO_GR03_1.x10.XA7.CN LELO_GR03_1.x10.XA6.MP1.S 0.02377f
C1163 LELO_GR03_1.x7.x20.G LELO_GR03_1.x7.x8.S 0.2115f
C1164 uo_out<6> uo_out<5> 0.03102f
C1165 ui_in<0> ui_in<1> 0.03102f
C1166 a_11972_18060# LELO_GR03_1.x1.x18.S 0.03954f
C1167 LELO_GR03_1.x7.INN LELO_GR03_1.x1.x21.OUT 1.97799f
C1168 LELO_GR03_1.x12<1>.A a_15202_5544# 0.01881f
C1169 LELO_GR03_1.x1.x21.x6.S a_5192_8867# 0.01027f
C1170 a_7592_9867# a_6792_9667# 0.02954f
C1171 a_12614_12488# VDPWR 0.51948f
C1172 LELO_GR03_1.x7.x21.S LELO_GR03_1.x7.x20.G 9.41516f
C1173 a_26148_6248# LELO_GR03_1.x10.D 0.08649f
C1174 a_26988_4808# VDPWR 0.31091f
C1175 LELO_GR03_1.x7.PWRUP_N_1V8 a_14122_11042# 0.01469f
C1176 LELO_GR03_1.x1.x21.INP a_10620_5354# 0.01216f
C1177 LELO_GR03_1.x7.PWRUP_1V8 a_6792_9507# 0.10088f
C1178 a_10072_15560# VDPWR 0.4671f
C1179 a_17962_5768# VDPWR 0.56481f
C1180 LELO_GR03_1.x1.x18.G a_12732_14260# 0.01165f
C1181 a_23162_4968# a_23662_4868# 0.01086f
C1182 LELO_GR03_1.x7.x21.S a_23662_2468# 0.05519f
C1183 LELO_GR03_1.x10.XA7.C LELO_GR03_1.x10.XA6.MP1.S 0.02158f
C1184 LELO_GR03_1.x10.CK LELO_GR03_1.x7.x8.S 0.95048f
C1185 LELO_GR03_1.x10.XA7.CN LELO_GR03_1.x10.XA6.A 0.66281f
C1186 a_11746_5544# VDPWR 0.01131f
C1187 LELO_GR03_1.x7.VB_N a_17962_3768# 0.07046f
C1188 a_11972_18060# LELO_GR03_1.x7.PWRUP_N_1V8 0.08427f
C1189 LELO_GR03_1.x7.INN a_8932_17200# 0.01441f
C1190 LELO_GR03_1.x1.VB_P a_13258_11042# 0.01378f
C1191 LELO_GR03_1.x1.x21.x6.S a_5192_9027# 0.03815f
C1192 a_12614_12648# VDPWR 0.6578f
C1193 LELO_GR03_1.x7.x21.S LELO_GR03_1.x10.CK 0.49349f
C1194 LELO_GR03_1.x7.PWRUP_N_1V8 a_13906_9122# 0.017f
C1195 LELO_GR03_1.x7.INN LELO_GR03_1.BIAS_CIRCUIT2_0.xa6.N 0.37639f
C1196 LELO_GR03_1.x7.PWRUP_1V8 a_6792_9667# 0.0158f
C1197 a_13258_7464# a_13690_7464# 0.21349f
C1198 a_11212_16360# VDPWR 0.49859f
C1199 LELO_GR03_1.x7.x20.G VDPWR 12.0705f
C1200 a_17962_2968# a_18262_2768# 0.01415f
C1201 LELO_GR03_1.x7.INN LELO_GR03_1.x1.VB_P 2.42852f
C1202 LELO_GR03_1.x1.x21.OUT LELO_GR03_1.x1.x21.x11<1>.A 10.2482f
C1203 a_5192_14683# a_5192_14523# 0.15007f
C1204 ena VGND 0.06659f
C1205 clk VGND 0.04284f
C1206 rst_n VGND 0.04203f
C1207 ui_in<1> VGND 0.04306f
C1208 ui_in<2> VGND 0.04259f
C1209 ui_in<3> VGND 0.04259f
C1210 ui_in<4> VGND 0.04259f
C1211 ui_in<5> VGND 0.04259f
C1212 ui_in<6> VGND 0.04259f
C1213 ui_in<7> VGND 0.04259f
C1214 uio_in<0> VGND 0.04259f
C1215 uio_in<1> VGND 0.04259f
C1216 uio_in<2> VGND 0.04259f
C1217 uio_in<3> VGND 0.04259f
C1218 uio_in<4> VGND 0.04259f
C1219 uio_in<5> VGND 0.04259f
C1220 uio_in<6> VGND 0.04259f
C1221 uio_in<7> VGND 0.04259f
C1222 uo_out<1> VGND 0.04259f
C1223 uo_out<2> VGND 0.04259f
C1224 uo_out<3> VGND 0.04259f
C1225 uo_out<4> VGND 0.04259f
C1226 uo_out<5> VGND 0.04259f
C1227 uo_out<6> VGND 0.04259f
C1228 uo_out<7> VGND 0.04259f
C1229 uio_out<0> VGND 0.04259f
C1230 uio_out<1> VGND 0.04259f
C1231 uio_out<2> VGND 0.04259f
C1232 uio_out<3> VGND 0.04259f
C1233 uio_out<4> VGND 0.04259f
C1234 uio_out<5> VGND 0.04259f
C1235 uio_out<6> VGND 0.04259f
C1236 uio_out<7> VGND 0.04259f
C1237 uio_oe<0> VGND 0.08799f
C1238 uio_oe<1> VGND 0.05524f
C1239 uio_oe<2> VGND 0.05462f
C1240 uio_oe<3> VGND 0.05357f
C1241 uio_oe<4> VGND 0.05232f
C1242 uio_oe<5> VGND 0.05274f
C1243 uio_oe<6> VGND 0.05462f
C1244 uio_oe<7> VGND 0.11114f
C1245 uo_out<0> VGND 10.6913f
C1246 ui_in<0> VGND 8.32226f
C1247 VDPWR VGND 0.30294p
C1248 m4_9998_21812# VGND 0.01451f $ **FLOATING
C1249 m4_6134_21830# VGND 0.01451f $ **FLOATING
C1250 li_6290_10467# VGND 0.07212f $ **FLOATING
C1251 a_21462_1968# VGND 0.66549f $ **FLOATING
C1252 a_26988_2408# VGND 0.08176f $ **FLOATING
C1253 a_26148_2408# VGND 0.44705f $ **FLOATING
C1254 a_26148_2728# VGND 0.40396f $ **FLOATING
C1255 LELO_GR03_1.x10.XA1.MN1.S VGND 0.09688f
C1256 a_26148_3208# VGND 0.31166f $ **FLOATING
C1257 a_26148_3528# VGND 0.31439f $ **FLOATING
C1258 LELO_GR03_1.x10.XA3.MN1.S VGND 0.09448f
C1259 a_26148_4008# VGND 0.31586f $ **FLOATING
C1260 LELO_GR03_1.x10.XA4.MN1.S VGND 0.08682f
C1261 a_26148_4488# VGND 0.31072f $ **FLOATING
C1262 LELO_GR03_1.x10.XA5.A VGND 0.99509f
C1263 a_26148_4808# VGND 0.31389f $ **FLOATING
C1264 a_23662_2468# VGND 0.11352f $ **FLOATING
C1265 a_19862_1968# VGND 0.84954f $ **FLOATING
C1266 a_19862_2128# VGND 0.67996f $ **FLOATING
C1267 a_18262_1968# VGND 0.85014f $ **FLOATING
C1268 a_18262_2128# VGND 0.67968f $ **FLOATING
C1269 a_16662_1968# VGND 0.85008f $ **FLOATING
C1270 a_16662_2128# VGND 0.68161f $ **FLOATING
C1271 a_21462_2768# VGND 0.61462f $ **FLOATING
C1272 a_19862_2608# VGND 0.67541f $ **FLOATING
C1273 a_19862_2768# VGND 0.76754f $ **FLOATING
C1274 a_18262_2608# VGND 0.67449f $ **FLOATING
C1275 a_18262_2768# VGND 0.76872f $ **FLOATING
C1276 a_16662_2608# VGND 0.67458f $ **FLOATING
C1277 a_16662_2768# VGND 0.74203f $ **FLOATING
C1278 a_14828_2276# VGND 0.83097f $ **FLOATING
C1279 a_14828_2436# VGND 0.68466f $ **FLOATING
C1280 a_13420_2276# VGND 0.83098f $ **FLOATING
C1281 a_13420_2436# VGND 0.68464f $ **FLOATING
C1282 a_21862_2968# VGND 0.62333f $ **FLOATING
C1283 LELO_GR03_1.x7.x10.D VGND 3.48979f
C1284 a_20562_2968# VGND 0.63565f $ **FLOATING
C1285 a_21862_3768# VGND 0.46603f $ **FLOATING
C1286 a_19262_2968# VGND 0.66826f $ **FLOATING
C1287 a_20562_3768# VGND 0.46613f $ **FLOATING
C1288 a_21862_4568# VGND 0.57741f $ **FLOATING
C1289 a_17962_2968# VGND 0.67427f $ **FLOATING
C1290 a_19262_3768# VGND 0.46613f $ **FLOATING
C1291 a_20562_4568# VGND 0.57752f $ **FLOATING
C1292 a_16662_2968# VGND 0.57786f $ **FLOATING
C1293 a_17962_3768# VGND 0.46613f $ **FLOATING
C1294 a_19262_4568# VGND 0.57752f $ **FLOATING
C1295 a_14828_2916# VGND 0.67855f $ **FLOATING
C1296 a_14828_3076# VGND 0.79095f $ **FLOATING
C1297 a_13420_2916# VGND 0.67687f $ **FLOATING
C1298 a_13420_3076# VGND 0.77326f $ **FLOATING
C1299 LELO_GR03_1.x7.x8.S VGND 8.0828f
C1300 a_16662_3768# VGND 0.46661f $ **FLOATING
C1301 a_17962_4568# VGND 0.57752f $ **FLOATING
C1302 a_14732_3308# VGND 0.6587f $ **FLOATING
C1303 a_13424_3308# VGND 0.57975f $ **FLOATING
C1304 LELO_GR03_1.BIAS_CIRCUIT2_0.xb6.S VGND 2.17362f
C1305 a_14732_4108# VGND 0.52663f $ **FLOATING
C1306 LELO_GR03_1.BIAS_CIRCUIT2_0.xc2.S VGND 2.10929f
C1307 a_13424_4108# VGND 0.52182f $ **FLOATING
C1308 LELO_GR03_1.x7.x7<2>.S VGND 3.48264f
C1309 a_16662_4568# VGND 0.57799f $ **FLOATING
C1310 a_14732_4270# VGND 0.59476f $ **FLOATING
C1311 a_23662_4868# VGND 0.03221f $ **FLOATING
C1312 LELO_GR03_1.x10.XA6.A VGND 0.97505f
C1313 LELO_GR03_1.x10.XA6.MN1.S VGND 0.08222f
C1314 a_26148_5288# VGND 0.31612f $ **FLOATING
C1315 LELO_GR03_1.x10.XA7.MN0.S VGND 0.09787f
C1316 LELO_GR03_1.x10.XA7.MP1.S VGND 0.12071f
C1317 LELO_GR03_1.x10.XA7.CN VGND 1.4416f
C1318 LELO_GR03_1.x10.XA7.C VGND 2.58085f
C1319 a_23162_4968# VGND 0.02437f $ **FLOATING
C1320 a_21862_4968# VGND 0.07579f $ **FLOATING
C1321 a_23162_5768# VGND 0.02581f $ **FLOATING
C1322 a_20562_4968# VGND 0.07579f $ **FLOATING
C1323 a_19262_4968# VGND 0.07579f $ **FLOATING
C1324 a_17962_4968# VGND 0.07579f $ **FLOATING
C1325 a_16662_4968# VGND 0.07798f $ **FLOATING
C1326 LELO_GR03_1.x7.x20.G VGND 4.29281f
C1327 LELO_GR03_1.x10.CK VGND 11.436f
C1328 a_13430_4262# VGND 0.5947f $ **FLOATING
C1329 a_14732_5070# VGND 0.61761f $ **FLOATING
C1330 a_13430_5062# VGND 0.61568f $ **FLOATING
C1331 a_12610_2046# VGND 1.87477f $ **FLOATING
C1332 LELO_GR03_1.x7.VB_N VGND 10.4012f
C1333 a_12178_2046# VGND 0.5348f
C1334 a_11962_3966# VGND 0.63171f
C1335 a_11746_2046# VGND 0.5342f
C1336 a_11530_2046# VGND 1.85509f $ **FLOATING
C1337 a_26148_5928# VGND 0.31234f $ **FLOATING
C1338 LELO_GR03_1.x10.D VGND 2.5924f
C1339 a_26988_6248# VGND 0.08095f $ **FLOATING
C1340 a_26148_6248# VGND 0.34856f $ **FLOATING
C1341 a_22462_6768# VGND 0.14116f $ **FLOATING
C1342 a_20862_6768# VGND 0.13909f $ **FLOATING
C1343 a_19262_6768# VGND 0.13909f $ **FLOATING
C1344 a_17962_6768# VGND 0.10637f $ **FLOATING
C1345 LELO_GR03_1.x7.x6.G VGND 5.3337f
C1346 LELO_GR03_1.x7.x21.G VGND 3.44672f
C1347 LELO_GR03_1.x7.x21.S VGND 0.40168f
C1348 a_16662_6768# VGND 0.10795f $ **FLOATING
C1349 a_15202_5544# VGND 1.88175f $ **FLOATING
C1350 a_14770_5544# VGND 0.52984f
C1351 a_14554_7464# VGND 0.63171f
C1352 a_14338_5544# VGND 0.43595f
C1353 a_14122_7464# VGND 0.63171f
C1354 a_13906_5544# VGND 0.43595f
C1355 a_13690_7464# VGND 0.63171f
C1356 a_13474_5544# VGND 0.4391f
C1357 a_13258_7464# VGND 0.63171f
C1358 a_13042_5544# VGND 0.43595f
C1359 a_12826_7464# VGND 0.63171f
C1360 a_12610_5544# VGND 0.43595f
C1361 a_12394_7464# VGND 0.63171f
C1362 a_12178_5544# VGND 0.43595f
C1363 a_11962_7464# VGND 0.63171f
C1364 a_11746_5544# VGND 0.52984f
C1365 LELO_GR03_1.BIAS_CIRCUIT2_0.xa5.N VGND 2.47253f
C1366 a_11530_5544# VGND 1.85576f $ **FLOATING
C1367 a_10620_5354# VGND 1.79084f $ **FLOATING
C1368 a_10188_5354# VGND 0.62373f
C1369 a_9972_5354# VGND 1.8398f $ **FLOATING
C1370 LELO_GR03_1.x1.XQ2.Emitter VGND 51.043f
C1371 a_15202_9122# VGND 1.89085f $ **FLOATING
C1372 LELO_GR03_1.BIAS_CIRCUIT2_0.xa6.N VGND 2.75119f
C1373 a_14770_9122# VGND 0.54117f
C1374 a_14554_11042# VGND 0.63753f
C1375 a_14338_9122# VGND 0.44285f
C1376 a_14122_11042# VGND 0.63533f
C1377 a_13906_9122# VGND 0.43778f
C1378 a_13690_11042# VGND 0.63171f
C1379 a_13474_9122# VGND 0.43595f
C1380 a_13258_11042# VGND 0.63171f
C1381 a_13042_9122# VGND 0.43595f
C1382 a_12826_11042# VGND 0.63171f
C1383 a_12610_9122# VGND 0.43595f
C1384 a_12394_11042# VGND 0.63171f
C1385 a_12178_9122# VGND 0.43595f
C1386 a_11962_11042# VGND 0.63171f
C1387 a_11746_9122# VGND 0.52984f
C1388 a_11530_9122# VGND 1.89258f $ **FLOATING
C1389 a_8392_8867# VGND 0.86819f $ **FLOATING
C1390 a_8392_9027# VGND 0.67704f $ **FLOATING
C1391 a_6792_8867# VGND 0.86869f $ **FLOATING
C1392 a_6792_9027# VGND 0.67618f $ **FLOATING
C1393 a_5192_8867# VGND 0.87151f $ **FLOATING
C1394 a_5192_9027# VGND 0.67784f $ **FLOATING
C1395 a_8392_9507# VGND 0.67352f $ **FLOATING
C1396 a_8392_9667# VGND 0.73928f $ **FLOATING
C1397 a_6792_9507# VGND 0.67271f $ **FLOATING
C1398 a_6792_9667# VGND 0.7487f $ **FLOATING
C1399 a_5192_9507# VGND 0.67554f $ **FLOATING
C1400 a_5192_9667# VGND 0.76327f $ **FLOATING
C1401 a_8892_9867# VGND 0.58656f $ **FLOATING
C1402 a_7592_9867# VGND 0.6245f $ **FLOATING
C1403 a_8892_10667# VGND 0.6255f $ **FLOATING
C1404 a_6292_9867# VGND 0.6611f $ **FLOATING
C1405 a_7592_10667# VGND 0.62442f $ **FLOATING
C1406 a_4992_9867# VGND 0.80762f $ **FLOATING
C1407 LELO_GR03_1.x1.x21.x6.S VGND 5.17896f
C1408 a_6292_10667# VGND 0.6245f $ **FLOATING
C1409 a_4992_10667# VGND 0.78082f $ **FLOATING
C1410 a_8892_11283# VGND 0.09067f $ **FLOATING
C1411 a_7592_11283# VGND 0.08848f $ **FLOATING
C1412 a_14214_12488# VGND 0.16389f $ **FLOATING
C1413 a_12614_12488# VGND 0.16305f $ **FLOATING
C1414 a_11314_12488# VGND 0.12507f $ **FLOATING
C1415 LELO_GR03_1.BIAS_CIRCUIT2_0.xb7.D VGND 1.59076f
C1416 a_14214_13288# VGND 0.14194f $ **FLOATING
C1417 a_12614_13288# VGND 0.12797f $ **FLOATING
C1418 LELO_GR03_1.BIAS_CIRCUIT2_0.xc4.D VGND 0.82882f
C1419 a_11314_13288# VGND 0.09827f $ **FLOATING
C1420 a_6292_11283# VGND 0.08848f $ **FLOATING
C1421 LELO_GR03_1.x1.VB_P VGND 5.93992f
C1422 a_4992_11283# VGND 0.0899f $ **FLOATING
C1423 a_8892_13683# VGND 0.01462f $ **FLOATING
C1424 a_7592_13683# VGND 0.01242f $ **FLOATING
C1425 LELO_GR03_1.x1.x21.x4.G VGND 4.73983f
C1426 a_3932_8957# VGND 1.88073f $ **FLOATING
C1427 LELO_GR03_1.x1.x21.x6.G VGND 4.53315f
C1428 a_3500_8957# VGND 0.52984f
C1429 a_3284_10877# VGND 0.63171f
C1430 a_3068_8957# VGND 0.52984f
C1431 LELO_GR03_1.x1.x21.x11<1>.A VGND 5.45947f
C1432 a_2852_8957# VGND 1.86296f $ **FLOATING
C1433 a_12732_14260# VGND 0.64503f $ **FLOATING
C1434 a_16976_15088# VGND 0.08297f $ **FLOATING
C1435 a_16136_15088# VGND 0.36727f $ **FLOATING
C1436 a_11472_14260# VGND 0.70569f $ **FLOATING
C1437 a_12732_15060# VGND 0.60095f $ **FLOATING
C1438 LELO_GR03_1.x1.x15.G VGND 4.88419f
C1439 a_10212_14260# VGND 0.72942f $ **FLOATING
C1440 a_11472_15060# VGND 0.64527f $ **FLOATING
C1441 LELO_GR03_1.x1.x21.x3<1>.S VGND 0.18661f
C1442 a_8392_14683# VGND 0.1269f $ **FLOATING
C1443 a_6792_14683# VGND 0.14733f $ **FLOATING
C1444 a_5192_14683# VGND 0.1494f $ **FLOATING
C1445 a_10212_15060# VGND 0.64519f $ **FLOATING
C1446 LELO_GR03_1.x7.PWRUP_1V8 VGND 28.9989f
C1447 a_16976_15408# VGND 0.06561f $ **FLOATING
C1448 a_16136_15408# VGND 0.34051f $ **FLOATING
C1449 a_12412_15580# VGND 0.09905f $ **FLOATING
C1450 a_16980_16158# VGND 0.06525f $ **FLOATING
C1451 a_16140_16158# VGND 0.35589f $ **FLOATING
C1452 a_16980_16478# VGND 0.08059f $ **FLOATING
C1453 a_16140_16478# VGND 0.349f $ **FLOATING
C1454 a_11212_15560# VGND 0.08196f $ **FLOATING
C1455 LELO_GR03_1.x1.x18.G VGND 1.14043f
C1456 LELO_GR03_1.x12<1>.A VGND 41.0414f
C1457 a_10072_15560# VGND 0.07594f $ **FLOATING
C1458 a_12412_17180# VGND 0.0149f $ **FLOATING
C1459 LELO_GR03_1.x1.x9.D VGND 0.10471f
C1460 a_8932_15560# VGND 0.07695f $ **FLOATING
C1461 a_11212_17200# VGND 0.0108f $ **FLOATING
C1462 LELO_GR03_1.x1.x11.D VGND 0.06373f
C1463 LELO_GR03_1.x1.x17.D VGND 0.07702f
C1464 LELO_GR03_1.x1.x21.OUT VGND 15.1491f
C1465 LELO_GR03_1.x1.x18.S VGND 6.42471f
C1466 LELO_GR03_1.x7.PWRUP_N_1V8 VGND 16.956f
C1467 a_11972_18220# VGND 0.14116f $ **FLOATING
C1468 a_10452_18220# VGND 0.13909f $ **FLOATING
C1469 a_8932_18220# VGND 0.14134f $ **FLOATING
C1470 a_8092_15234# VGND 1.79035f $ **FLOATING
C1471 LELO_GR03_1.x7.INN VGND 12.5838f
C1472 a_7660_15234# VGND 0.52984f
C1473 a_7444_17154# VGND 0.63171f
C1474 a_7228_15234# VGND 0.52984f
C1475 LELO_GR03_1.x1.x21.INP VGND 4.75873f
C1476 a_7012_15234# VGND 1.81037f $ **FLOATING
C1477 a_6152_15234# VGND 1.81037f $ **FLOATING
C1478 LELO_GR03_1.x1.x14.D VGND 2.30718f
C1479 a_5720_15234# VGND 0.52984f
C1480 a_5504_17154# VGND 0.63171f
C1481 a_5288_15234# VGND 0.52984f
C1482 LELO_GR03_1.x1.XQ2<3>.Emitter VGND 6.12652f
C1483 a_5072_15234# VGND 1.85166f $ **FLOATING
C1484 a_28996_20830# VGND 0.09642f $ **FLOATING
C1485 a_28156_20830# VGND 0.44295f $ **FLOATING
C1486 a_28156_21150# VGND 0.39998f $ **FLOATING
C1487 JNWTR_TIEL_CV_0.MP0.G VGND 0.53365f
C1488 JNWTR_TIEL_CV_0.Y VGND 9.89066f
C1489 a_28996_21470# VGND 0.08187f $ **FLOATING
C1490 a_28156_21470# VGND 0.34452f $ **FLOATING
.ends
